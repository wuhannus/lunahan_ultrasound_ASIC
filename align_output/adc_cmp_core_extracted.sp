* SPICE3 file created from ADC_CMP_CORE_F.ext - technology: sky130A

X0 a_n818_n2397# a_n33_n5829# a_n110_n5633# VSUBS sky130_fd_pr__nfet_01v8 ad=3.8 pd=16.95 as=3.8 ps=16.95 w=8 l=0.15
X1 a_n640_397# a_n740_201# a_n818_n2397# VSUBS sky130_fd_pr__nfet_01v8 ad=1.65 pd=10.33 as=3.9 ps=20.78 w=10 l=0.5
X2 a_n818_n2397# a_n740_201# a_n640_397# VSUBS sky130_fd_pr__nfet_01v8 ad=1.65 pd=10.33 as=1.65 ps=10.33 w=10 l=0.5
X3 a_n818_n2397# a_n740_n2447# a_n640_n2397# VSUBS sky130_fd_pr__nfet_01v8 ad=1.65 pd=10.33 as=1.65 ps=10.33 w=10 l=0.5
X4 a_n818_n2397# a_n740_201# a_n640_397# VSUBS sky130_fd_pr__nfet_01v8 ad=3.9 pd=20.78 as=1.65 ps=10.33 w=10 l=0.5
X5 a_n818_n2397# a_n740_201# a_n640_397# VSUBS sky130_fd_pr__nfet_01v8 ad=3.9 pd=20.78 as=1.65 ps=10.33 w=10 l=0.5
X6 a_n640_n2397# a_n740_n2447# a_n818_n2397# VSUBS sky130_fd_pr__nfet_01v8 ad=1.65 pd=10.33 as=1.65 ps=10.33 w=10 l=0.5
X7 a_n818_n2397# a_n740_n2447# a_n640_n2397# VSUBS sky130_fd_pr__nfet_01v8 ad=3.9 pd=20.78 as=1.65 ps=10.33 w=10 l=0.5
X8 a_n640_n2397# a_n740_n2447# a_n818_n2397# VSUBS sky130_fd_pr__nfet_01v8 ad=1.65 pd=10.33 as=1.65 ps=10.33 w=10 l=0.5
X9 a_n640_397# a_n740_201# a_n818_n2397# VSUBS sky130_fd_pr__nfet_01v8 ad=1.65 pd=10.33 as=3.9 ps=20.78 w=10 l=0.5
X10 a_n640_397# a_n740_201# a_n818_n2397# VSUBS sky130_fd_pr__nfet_01v8 ad=1.65 pd=10.33 as=1.65 ps=10.33 w=10 l=0.5
X11 a_n640_n2397# a_n740_n2447# a_n818_n2397# VSUBS sky130_fd_pr__nfet_01v8 ad=1.65 pd=10.33 as=3.9 ps=20.78 w=10 l=0.5
X12 a_n640_397# a_n740_201# a_n818_n2397# VSUBS sky130_fd_pr__nfet_01v8 ad=1.65 pd=10.33 as=1.65 ps=10.33 w=10 l=0.5
X13 a_n640_n2397# a_n740_n2447# a_n818_n2397# VSUBS sky130_fd_pr__nfet_01v8 ad=1.65 pd=10.33 as=3.9 ps=20.78 w=10 l=0.5
X14 a_n818_n2397# a_n740_n2447# a_n640_n2397# VSUBS sky130_fd_pr__nfet_01v8 ad=1.65 pd=10.33 as=1.65 ps=10.33 w=10 l=0.5
X15 a_n818_n2397# a_n740_n2447# a_n640_n2397# VSUBS sky130_fd_pr__nfet_01v8 ad=3.9 pd=20.78 as=1.65 ps=10.33 w=10 l=0.5
X16 a_n818_n2397# a_n740_201# a_n640_397# VSUBS sky130_fd_pr__nfet_01v8 ad=1.65 pd=10.33 as=1.65 ps=10.33 w=10 l=0.5
C0 a_n740_201# a_n818_n2397# 3.88538f
C1 a_n740_201# a_n740_n2447# 4.01779f
C2 a_n818_n2397# a_n640_n2397# 10.7515f
C3 a_n818_n2397# a_n640_397# 10.8273f
C4 a_n740_n2447# a_n640_n2397# 4.34137f
C5 a_n740_n2447# a_n818_n2397# 3.84423f
C6 a_n740_201# a_n640_397# 4.77979f
C7 a_n818_n2397# VSUBS 8.115f **FLOATING
C8 a_n740_n2447# VSUBS 4.18836f **FLOATING
C9 a_n740_201# VSUBS 3.69575f **FLOATING
