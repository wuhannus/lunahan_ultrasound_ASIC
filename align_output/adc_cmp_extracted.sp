* SPICE3 file created from ADC_CMP_F.ext - technology: sky130A

X0 a_n357_n2673# a_n405_n2869# a_n482_n2673# VSUBS sky130_fd_pr__nfet_01v8 ad=2.85 pd=12.95 as=2.85 ps=12.95 w=6 l=0.15
X1 a_n818_n8968# a_n33_n12400# a_n110_n12204# VSUBS sky130_fd_pr__nfet_01v8 ad=3.8 pd=16.95 as=3.8 ps=16.95 w=8 l=0.15
X2 a_n818_n8968# a_n740_n9018# a_n818_n8968# VSUBS sky130_fd_pr__nfet_01v8 ad=3.9 pd=20.78 as=74.6 ps=431.10999 w=10 l=0.5
X3 a_n818_n8968# a_n740_n9018# a_n818_n8968# VSUBS sky130_fd_pr__nfet_01v8 ad=1.65 pd=10.33 as=0 ps=0 w=10 l=0.5
X4 a_n818_n8968# a_n740_n6370# a_n818_n8968# VSUBS sky130_fd_pr__nfet_01v8 ad=3.9 pd=20.78 as=0 ps=0 w=10 l=0.5
X5 a_n818_n8968# a_n740_n6370# a_n818_n8968# VSUBS sky130_fd_pr__nfet_01v8 ad=1.65 pd=10.33 as=0 ps=0 w=10 l=0.5
X6 a_n818_n8968# a_n740_n9018# a_n818_n8968# VSUBS sky130_fd_pr__nfet_01v8 ad=1.65 pd=10.33 as=0 ps=0 w=10 l=0.5
X7 a_n818_n8968# a_n740_n6370# a_n818_n8968# VSUBS sky130_fd_pr__nfet_01v8 ad=1.65 pd=10.33 as=0 ps=0 w=10 l=0.5
X8 a_n818_n8968# a_n740_n6370# a_n818_n8968# VSUBS sky130_fd_pr__nfet_01v8 ad=1.65 pd=10.33 as=0 ps=0 w=10 l=0.5
X9 a_n818_n8968# a_n740_n6370# a_n818_n8968# VSUBS sky130_fd_pr__nfet_01v8 ad=1.65 pd=10.33 as=0 ps=0 w=10 l=0.5
X10 a_n818_n8968# a_n740_n9018# a_n818_n8968# VSUBS sky130_fd_pr__nfet_01v8 ad=1.65 pd=10.33 as=0 ps=0 w=10 l=0.5
X11 a_n818_n8968# a_n740_n9018# a_n818_n8968# VSUBS sky130_fd_pr__nfet_01v8 ad=1.65 pd=10.33 as=0 ps=0 w=10 l=0.5
X12 a_387_n2673# a_339_n2869# a_262_n2673# VSUBS sky130_fd_pr__nfet_01v8 ad=2.85 pd=12.95 as=2.85 ps=12.95 w=6 l=0.15
X13 a_387_n200# a_339_n396# a_262_n200# w_200_n436# sky130_fd_pr__pfet_01v8 ad=0.95 pd=4.95 as=0.95 ps=4.95 w=2 l=0.15
X14 a_n818_n8968# a_n740_n9018# a_n818_n8968# VSUBS sky130_fd_pr__nfet_01v8 ad=1.65 pd=10.33 as=0 ps=0 w=10 l=0.5
X15 a_n818_n8968# a_n740_n6370# a_n818_n8968# VSUBS sky130_fd_pr__nfet_01v8 ad=1.65 pd=10.33 as=0 ps=0 w=10 l=0.5
X16 a_n818_n8968# a_n740_n6370# a_n818_n8968# VSUBS sky130_fd_pr__nfet_01v8 ad=3.9 pd=20.78 as=0 ps=0 w=10 l=0.5
X17 a_n818_n8968# a_n740_n6370# a_n818_n8968# VSUBS sky130_fd_pr__nfet_01v8 ad=1.65 pd=10.33 as=0 ps=0 w=10 l=0.5
X18 a_n357_n200# a_n405_n396# a_n482_n200# w_n544_n436# sky130_fd_pr__pfet_01v8 ad=0.95 pd=4.95 as=0.95 ps=4.95 w=2 l=0.15
X19 a_n818_n8968# a_n740_n9018# a_n818_n8968# VSUBS sky130_fd_pr__nfet_01v8 ad=3.9 pd=20.78 as=0 ps=0 w=10 l=0.5
X20 a_n818_n8968# a_n740_n9018# a_n818_n8968# VSUBS sky130_fd_pr__nfet_01v8 ad=1.65 pd=10.33 as=0 ps=0 w=10 l=0.5
C0 a_n740_n9018# a_n818_n8968# 8.37037f
C1 a_n740_n6370# a_n818_n8968# 9.28916f
C2 a_n740_n6370# a_n740_n9018# 4.01779f
C3 a_n818_n8968# VSUBS 10.4383f **FLOATING
C4 a_n740_n9018# VSUBS 4.1686f **FLOATING
C5 a_n740_n6370# VSUBS 3.69488f **FLOATING
