* SPICE3 file created from ADC_FULL_F.ext - technology: sky130A

X0 a_n818_n18479# a_n740_n15881# a_n818_n18479# VSUBS sky130_fd_pr__nfet_01v8 ad=1.65 pd=10.33 as=74.6 ps=431.10999 w=10 l=0.5
X1 a_387_n8038# a_339_n8234# a_262_n8038# VSUBS sky130_fd_pr__nfet_01v8 ad=2.85 pd=12.95 as=2.85 ps=12.95 w=6 l=0.15
X2 a_n818_n18479# a_n740_n15881# a_n818_n18479# VSUBS sky130_fd_pr__nfet_01v8 ad=1.65 pd=10.33 as=0 ps=0 w=10 l=0.5
X3 a_n818_n18479# a_n740_n15881# a_n818_n18479# VSUBS sky130_fd_pr__nfet_01v8 ad=1.65 pd=10.33 as=0 ps=0 w=10 l=0.5
X4 a_n818_n18479# a_n740_n18529# a_n818_n18479# VSUBS sky130_fd_pr__nfet_01v8 ad=1.65 pd=10.33 as=0 ps=0 w=10 l=0.5
X5 a_n818_n18479# a_n740_n15881# a_n818_n18479# VSUBS sky130_fd_pr__nfet_01v8 ad=3.9 pd=20.78 as=0 ps=0 w=10 l=0.5
X6 a_n818_n18479# a_n740_n18529# a_n818_n18479# VSUBS sky130_fd_pr__nfet_01v8 ad=1.65 pd=10.33 as=0 ps=0 w=10 l=0.5
X7 c1_n1956_n500# m3_n1984_n528# sky130_fd_pr__cap_mim_m3_1 l=5 w=5
X8 a_n357_n5565# a_n405_n5761# a_n482_n5565# VSUBS sky130_fd_pr__nfet_01v8 ad=9.5 pd=40.95 as=9.5 ps=40.95 w=20 l=0.15
X9 c1_2412_n500# m3_2384_n528# sky130_fd_pr__cap_mim_m3_1 l=5 w=5
X10 a_n818_n18479# a_n740_n15881# a_n818_n18479# VSUBS sky130_fd_pr__nfet_01v8 ad=1.65 pd=10.33 as=0 ps=0 w=10 l=0.5
X11 a_n818_n18479# a_n740_n18529# a_n818_n18479# VSUBS sky130_fd_pr__nfet_01v8 ad=1.65 pd=10.33 as=0 ps=0 w=10 l=0.5
X12 a_n818_n18479# a_n740_n15881# a_n818_n18479# VSUBS sky130_fd_pr__nfet_01v8 ad=1.65 pd=10.33 as=0 ps=0 w=10 l=0.5
X13 a_n818_n18479# a_n740_n18529# a_n818_n18479# VSUBS sky130_fd_pr__nfet_01v8 ad=3.9 pd=20.78 as=0 ps=0 w=10 l=0.5
X14 c1_n500_n500# m3_n528_n528# sky130_fd_pr__cap_mim_m3_1 l=5 w=5
X15 a_387_n10511# a_339_n10707# a_262_n10511# w_200_n10747# sky130_fd_pr__pfet_01v8 ad=2.85 pd=12.95 as=2.85 ps=12.95 w=6 l=0.15
X16 a_n818_n18479# a_n740_n18529# a_n818_n18479# VSUBS sky130_fd_pr__nfet_01v8 ad=1.65 pd=10.33 as=0 ps=0 w=10 l=0.5
X17 a_387_n12184# a_339_n12380# a_262_n12184# w_200_n12420# sky130_fd_pr__pfet_01v8 ad=0.95 pd=4.95 as=0.95 ps=4.95 w=2 l=0.15
X18 a_n357_n8038# a_n405_n8234# a_n482_n8038# VSUBS sky130_fd_pr__nfet_01v8 ad=2.85 pd=12.95 as=2.85 ps=12.95 w=6 l=0.15
X19 a_n357_n10511# a_n405_n10707# a_n482_n10511# w_n544_n10747# sky130_fd_pr__pfet_01v8 ad=2.85 pd=12.95 as=2.85 ps=12.95 w=6 l=0.15
X20 a_n818_n18479# a_n740_n18529# a_n818_n18479# VSUBS sky130_fd_pr__nfet_01v8 ad=1.65 pd=10.33 as=0 ps=0 w=10 l=0.5
X21 a_n357_n12184# a_n405_n12380# a_n482_n12184# w_n544_n12420# sky130_fd_pr__pfet_01v8 ad=0.95 pd=4.95 as=0.95 ps=4.95 w=2 l=0.15
X22 a_387_n5565# a_339_n5761# a_262_n5565# VSUBS sky130_fd_pr__nfet_01v8 ad=9.5 pd=40.95 as=9.5 ps=40.95 w=20 l=0.15
X23 c1_n3412_n500# m3_n3440_n528# sky130_fd_pr__cap_mim_m3_1 l=5 w=5
X24 a_n818_n18479# a_n740_n18529# a_n818_n18479# VSUBS sky130_fd_pr__nfet_01v8 ad=3.9 pd=20.78 as=0 ps=0 w=10 l=0.5
X25 a_n818_n18479# a_n740_n15881# a_n818_n18479# VSUBS sky130_fd_pr__nfet_01v8 ad=1.65 pd=10.33 as=0 ps=0 w=10 l=0.5
X26 a_n818_n18479# a_n33_n21911# a_n110_n21715# VSUBS sky130_fd_pr__nfet_01v8 ad=3.8 pd=16.95 as=3.8 ps=16.95 w=8 l=0.15
X27 c1_956_n500# m3_928_n528# sky130_fd_pr__cap_mim_m3_1 l=5 w=5
X28 a_n818_n18479# a_n740_n18529# a_n818_n18479# VSUBS sky130_fd_pr__nfet_01v8 ad=1.65 pd=10.33 as=0 ps=0 w=10 l=0.5
X29 a_n818_n18479# a_n740_n15881# a_n818_n18479# VSUBS sky130_fd_pr__nfet_01v8 ad=3.9 pd=20.78 as=0 ps=0 w=10 l=0.5
C0 a_262_n5565# a_387_n5565# 2.94107f
C1 m3_n3440_n528# c1_n3412_n500# 2.30823f
C2 m3_2384_n528# c1_2412_n500# 2.30823f
C3 m3_928_n528# c1_956_n500# 2.30823f
C4 a_n482_n5565# a_n357_n5565# 2.94107f
C5 a_n740_n18529# a_n818_n18479# 8.37037f
C6 m3_n528_n528# c1_n500_n500# 2.30823f
C7 a_n740_n15881# a_n818_n18479# 9.28916f
C8 m3_n1984_n528# c1_n1956_n500# 2.30823f
C9 a_n740_n15881# a_n740_n18529# 4.01779f
C10 a_n818_n18479# VSUBS 10.4368f **FLOATING
C11 a_n740_n18529# VSUBS 4.15731f **FLOATING
C12 a_n740_n15881# VSUBS 3.69438f **FLOATING
