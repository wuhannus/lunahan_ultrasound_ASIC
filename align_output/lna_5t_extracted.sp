* NGSPICE file created from LNA_5T_CORE.ext - technology: sky130A

.option scale=10m

.subckt XMNL XMNL SUB
X0 a_30070_0# a_30010_n50# a_20040_0# SUB sky130_fd_pr__nfet_01v8 ad=15.952u pd=0.02314 as=15.952u ps=0.02314 w=1600 l=60
X1 a_50110_0# a_50050_n50# a_40080_0# SUB sky130_fd_pr__nfet_01v8 ad=15.952u pd=0.02314 as=15.952u ps=0.02314 w=1600 l=60
X2 a_10030_0# a_9970_n50# a_0_0# SUB sky130_fd_pr__nfet_01v8 ad=15.952u pd=0.02314 as=15.952u ps=0.02314 w=1600 l=60
.ends

.subckt XMT XMT
X0 a_190390_0# a_190330_n50# a_180360_0# w_n120_n120# sky130_fd_pr__pfet_01v8 ad=3.988u pd=0.02074 as=3.988u ps=0.02074 w=400 l=60
X1 a_210430_0# a_210370_n50# a_200400_0# w_n120_n120# sky130_fd_pr__pfet_01v8 ad=3.988u pd=0.02074 as=3.988u ps=0.02074 w=400 l=60
X2 a_250510_0# a_250450_n50# a_240480_0# w_n120_n120# sky130_fd_pr__pfet_01v8 ad=3.988u pd=0.02074 as=3.988u ps=0.02074 w=400 l=60
X3 a_290590_0# a_290530_n50# a_280560_0# w_n120_n120# sky130_fd_pr__pfet_01v8 ad=3.988u pd=0.02074 as=3.988u ps=0.02074 w=400 l=60
X4 a_310630_0# a_310570_n50# a_300600_0# w_n120_n120# sky130_fd_pr__pfet_01v8 ad=3.988u pd=0.02074 as=3.988u ps=0.02074 w=400 l=60
X5 a_170350_0# a_170290_n50# a_160320_0# w_n120_n120# sky130_fd_pr__pfet_01v8 ad=3.988u pd=0.02074 as=3.988u ps=0.02074 w=400 l=60
X6 a_30070_0# a_30010_n50# a_20040_0# w_n120_n120# sky130_fd_pr__pfet_01v8 ad=3.988u pd=0.02074 as=3.988u ps=0.02074 w=400 l=60
X7 a_270550_0# a_270490_n50# a_260520_0# w_n120_n120# sky130_fd_pr__pfet_01v8 ad=3.988u pd=0.02074 as=3.988u ps=0.02074 w=400 l=60
X8 a_50110_0# a_50050_n50# a_40080_0# w_n120_n120# sky130_fd_pr__pfet_01v8 ad=3.988u pd=0.02074 as=3.988u ps=0.02074 w=400 l=60
X9 a_90190_0# a_90130_n50# a_80160_0# w_n120_n120# sky130_fd_pr__pfet_01v8 ad=3.988u pd=0.02074 as=3.988u ps=0.02074 w=400 l=60
X10 a_10030_0# a_9970_n50# a_0_0# w_n120_n120# sky130_fd_pr__pfet_01v8 ad=3.988u pd=0.02074 as=3.988u ps=0.02074 w=400 l=60
X11 a_130270_0# a_130210_n50# a_120240_0# w_n120_n120# sky130_fd_pr__pfet_01v8 ad=3.988u pd=0.02074 as=3.988u ps=0.02074 w=400 l=60
X12 a_70150_0# a_70090_n50# a_60120_0# w_n120_n120# sky130_fd_pr__pfet_01v8 ad=3.988u pd=0.02074 as=3.988u ps=0.02074 w=400 l=60
X13 a_230470_0# a_230410_n50# a_220440_0# w_n120_n120# sky130_fd_pr__pfet_01v8 ad=3.988u pd=0.02074 as=3.988u ps=0.02074 w=400 l=60
X14 a_110230_0# a_110170_n50# a_100200_0# w_n120_n120# sky130_fd_pr__pfet_01v8 ad=3.988u pd=0.02074 as=3.988u ps=0.02074 w=400 l=60
X15 a_150310_0# a_150250_n50# a_140280_0# w_n120_n120# sky130_fd_pr__pfet_01v8 ad=3.988u pd=0.02074 as=3.988u ps=0.02074 w=400 l=60
.ends

.subckt XM1
X0 a_190390_0# a_190330_n50# a_180360_0# w_n120_n120# sky130_fd_pr__pfet_01v8 ad=3.988u pd=0.02074 as=3.988u ps=0.02074 w=400 l=60
X1 a_210430_0# a_210370_n50# a_200400_0# w_n120_n120# sky130_fd_pr__pfet_01v8 ad=3.988u pd=0.02074 as=3.988u ps=0.02074 w=400 l=60
X2 a_430870_0# a_430810_n50# a_420840_0# w_n120_n120# sky130_fd_pr__pfet_01v8 ad=3.988u pd=0.02074 as=3.988u ps=0.02074 w=400 l=60
X3 a_250510_0# a_250450_n50# a_240480_0# w_n120_n120# sky130_fd_pr__pfet_01v8 ad=3.988u pd=0.02074 as=3.988u ps=0.02074 w=400 l=60
X4 a_531070_0# a_531010_n50# a_521040_0# w_n120_n120# sky130_fd_pr__pfet_01v8 ad=3.988u pd=0.02074 as=3.988u ps=0.02074 w=400 l=60
X5 a_290590_0# a_290530_n50# a_280560_0# w_n120_n120# sky130_fd_pr__pfet_01v8 ad=3.988u pd=0.02074 as=3.988u ps=0.02074 w=400 l=60
X6 a_310630_0# a_310570_n50# a_300600_0# w_n120_n120# sky130_fd_pr__pfet_01v8 ad=3.988u pd=0.02074 as=3.988u ps=0.02074 w=400 l=60
X7 a_350710_0# a_350650_n50# a_340680_0# w_n120_n120# sky130_fd_pr__pfet_01v8 ad=3.988u pd=0.02074 as=3.988u ps=0.02074 w=400 l=60
X8 a_170350_0# a_170290_n50# a_160320_0# w_n120_n120# sky130_fd_pr__pfet_01v8 ad=3.988u pd=0.02074 as=3.988u ps=0.02074 w=400 l=60
X9 a_30070_0# a_30010_n50# a_20040_0# w_n120_n120# sky130_fd_pr__pfet_01v8 ad=3.988u pd=0.02074 as=3.988u ps=0.02074 w=400 l=60
X10 a_390790_0# a_390730_n50# a_380760_0# w_n120_n120# sky130_fd_pr__pfet_01v8 ad=3.988u pd=0.02074 as=3.988u ps=0.02074 w=400 l=60
X11 a_410830_0# a_410770_n50# a_400800_0# w_n120_n120# sky130_fd_pr__pfet_01v8 ad=3.988u pd=0.02074 as=3.988u ps=0.02074 w=400 l=60
X12 a_631270_0# a_631210_n50# a_621240_0# w_n120_n120# sky130_fd_pr__pfet_01v8 ad=3.988u pd=0.02074 as=3.988u ps=0.02074 w=400 l=60
X13 a_450910_0# a_450850_n50# a_440880_0# w_n120_n120# sky130_fd_pr__pfet_01v8 ad=3.988u pd=0.02074 as=3.988u ps=0.02074 w=400 l=60
X14 a_270550_0# a_270490_n50# a_260520_0# w_n120_n120# sky130_fd_pr__pfet_01v8 ad=3.988u pd=0.02074 as=3.988u ps=0.02074 w=400 l=60
X15 a_490990_0# a_490930_n50# a_480960_0# w_n120_n120# sky130_fd_pr__pfet_01v8 ad=3.988u pd=0.02074 as=3.988u ps=0.02074 w=400 l=60
X16 a_511030_0# a_510970_n50# a_501000_0# w_n120_n120# sky130_fd_pr__pfet_01v8 ad=3.988u pd=0.02074 as=3.988u ps=0.02074 w=400 l=60
X17 a_551110_0# a_551050_n50# a_541080_0# w_n120_n120# sky130_fd_pr__pfet_01v8 ad=3.988u pd=0.02074 as=3.988u ps=0.02074 w=400 l=60
X18 a_591190_0# a_591130_n50# a_581160_0# w_n120_n120# sky130_fd_pr__pfet_01v8 ad=3.988u pd=0.02074 as=3.988u ps=0.02074 w=400 l=60
X19 a_611230_0# a_611170_n50# a_601200_0# w_n120_n120# sky130_fd_pr__pfet_01v8 ad=3.988u pd=0.02074 as=3.988u ps=0.02074 w=400 l=60
X20 a_370750_0# a_370690_n50# a_360720_0# w_n120_n120# sky130_fd_pr__pfet_01v8 ad=3.988u pd=0.02074 as=3.988u ps=0.02074 w=400 l=60
X21 a_50110_0# a_50050_n50# a_40080_0# w_n120_n120# sky130_fd_pr__pfet_01v8 ad=3.988u pd=0.02074 as=3.988u ps=0.02074 w=400 l=60
X22 a_90190_0# a_90130_n50# a_80160_0# w_n120_n120# sky130_fd_pr__pfet_01v8 ad=3.988u pd=0.02074 as=3.988u ps=0.02074 w=400 l=60
X23 a_470950_0# a_470890_n50# a_460920_0# w_n120_n120# sky130_fd_pr__pfet_01v8 ad=3.988u pd=0.02074 as=3.988u ps=0.02074 w=400 l=60
X24 a_10030_0# a_9970_n50# a_0_0# w_n120_n120# sky130_fd_pr__pfet_01v8 ad=3.988u pd=0.02074 as=3.988u ps=0.02074 w=400 l=60
X25 a_571150_0# a_571090_n50# a_561120_0# w_n120_n120# sky130_fd_pr__pfet_01v8 ad=3.988u pd=0.02074 as=3.988u ps=0.02074 w=400 l=60
X26 a_130270_0# a_130210_n50# a_120240_0# w_n120_n120# sky130_fd_pr__pfet_01v8 ad=3.988u pd=0.02074 as=3.988u ps=0.02074 w=400 l=60
X27 a_70150_0# a_70090_n50# a_60120_0# w_n120_n120# sky130_fd_pr__pfet_01v8 ad=3.988u pd=0.02074 as=3.988u ps=0.02074 w=400 l=60
X28 a_230470_0# a_230410_n50# a_220440_0# w_n120_n120# sky130_fd_pr__pfet_01v8 ad=3.988u pd=0.02074 as=3.988u ps=0.02074 w=400 l=60
X29 a_110230_0# a_110170_n50# a_100200_0# w_n120_n120# sky130_fd_pr__pfet_01v8 ad=3.988u pd=0.02074 as=3.988u ps=0.02074 w=400 l=60
X30 a_330670_0# a_330610_n50# a_320640_0# w_n120_n120# sky130_fd_pr__pfet_01v8 ad=3.988u pd=0.02074 as=3.988u ps=0.02074 w=400 l=60
X31 a_150310_0# a_150250_n50# a_140280_0# w_n120_n120# sky130_fd_pr__pfet_01v8 ad=3.988u pd=0.02074 as=3.988u ps=0.02074 w=400 l=60
.ends

.subckt XM2
X0 a_190390_0# a_190330_n50# a_180360_0# w_n120_n120# sky130_fd_pr__pfet_01v8 ad=3.988u pd=0.02074 as=3.988u ps=0.02074 w=400 l=60
X1 a_210430_0# a_210370_n50# a_200400_0# w_n120_n120# sky130_fd_pr__pfet_01v8 ad=3.988u pd=0.02074 as=3.988u ps=0.02074 w=400 l=60
X2 a_430870_0# a_430810_n50# a_420840_0# w_n120_n120# sky130_fd_pr__pfet_01v8 ad=3.988u pd=0.02074 as=3.988u ps=0.02074 w=400 l=60
X3 a_250510_0# a_250450_n50# a_240480_0# w_n120_n120# sky130_fd_pr__pfet_01v8 ad=3.988u pd=0.02074 as=3.988u ps=0.02074 w=400 l=60
X4 a_531070_0# a_531010_n50# a_521040_0# w_n120_n120# sky130_fd_pr__pfet_01v8 ad=3.988u pd=0.02074 as=3.988u ps=0.02074 w=400 l=60
X5 a_290590_0# a_290530_n50# a_280560_0# w_n120_n120# sky130_fd_pr__pfet_01v8 ad=3.988u pd=0.02074 as=3.988u ps=0.02074 w=400 l=60
X6 a_310630_0# a_310570_n50# a_300600_0# w_n120_n120# sky130_fd_pr__pfet_01v8 ad=3.988u pd=0.02074 as=3.988u ps=0.02074 w=400 l=60
X7 a_350710_0# a_350650_n50# a_340680_0# w_n120_n120# sky130_fd_pr__pfet_01v8 ad=3.988u pd=0.02074 as=3.988u ps=0.02074 w=400 l=60
X8 a_170350_0# a_170290_n50# a_160320_0# w_n120_n120# sky130_fd_pr__pfet_01v8 ad=3.988u pd=0.02074 as=3.988u ps=0.02074 w=400 l=60
X9 a_30070_0# a_30010_n50# a_20040_0# w_n120_n120# sky130_fd_pr__pfet_01v8 ad=3.988u pd=0.02074 as=3.988u ps=0.02074 w=400 l=60
X10 a_390790_0# a_390730_n50# a_380760_0# w_n120_n120# sky130_fd_pr__pfet_01v8 ad=3.988u pd=0.02074 as=3.988u ps=0.02074 w=400 l=60
X11 a_410830_0# a_410770_n50# a_400800_0# w_n120_n120# sky130_fd_pr__pfet_01v8 ad=3.988u pd=0.02074 as=3.988u ps=0.02074 w=400 l=60
X12 a_631270_0# a_631210_n50# a_621240_0# w_n120_n120# sky130_fd_pr__pfet_01v8 ad=3.988u pd=0.02074 as=3.988u ps=0.02074 w=400 l=60
X13 a_450910_0# a_450850_n50# a_440880_0# w_n120_n120# sky130_fd_pr__pfet_01v8 ad=3.988u pd=0.02074 as=3.988u ps=0.02074 w=400 l=60
X14 a_270550_0# a_270490_n50# a_260520_0# w_n120_n120# sky130_fd_pr__pfet_01v8 ad=3.988u pd=0.02074 as=3.988u ps=0.02074 w=400 l=60
X15 a_490990_0# a_490930_n50# a_480960_0# w_n120_n120# sky130_fd_pr__pfet_01v8 ad=3.988u pd=0.02074 as=3.988u ps=0.02074 w=400 l=60
X16 a_511030_0# a_510970_n50# a_501000_0# w_n120_n120# sky130_fd_pr__pfet_01v8 ad=3.988u pd=0.02074 as=3.988u ps=0.02074 w=400 l=60
X17 a_551110_0# a_551050_n50# a_541080_0# w_n120_n120# sky130_fd_pr__pfet_01v8 ad=3.988u pd=0.02074 as=3.988u ps=0.02074 w=400 l=60
X18 a_591190_0# a_591130_n50# a_581160_0# w_n120_n120# sky130_fd_pr__pfet_01v8 ad=3.988u pd=0.02074 as=3.988u ps=0.02074 w=400 l=60
X19 a_611230_0# a_611170_n50# a_601200_0# w_n120_n120# sky130_fd_pr__pfet_01v8 ad=3.988u pd=0.02074 as=3.988u ps=0.02074 w=400 l=60
X20 a_370750_0# a_370690_n50# a_360720_0# w_n120_n120# sky130_fd_pr__pfet_01v8 ad=3.988u pd=0.02074 as=3.988u ps=0.02074 w=400 l=60
X21 a_50110_0# a_50050_n50# a_40080_0# w_n120_n120# sky130_fd_pr__pfet_01v8 ad=3.988u pd=0.02074 as=3.988u ps=0.02074 w=400 l=60
X22 a_90190_0# a_90130_n50# a_80160_0# w_n120_n120# sky130_fd_pr__pfet_01v8 ad=3.988u pd=0.02074 as=3.988u ps=0.02074 w=400 l=60
X23 a_470950_0# a_470890_n50# a_460920_0# w_n120_n120# sky130_fd_pr__pfet_01v8 ad=3.988u pd=0.02074 as=3.988u ps=0.02074 w=400 l=60
X24 a_10030_0# a_9970_n50# a_0_0# w_n120_n120# sky130_fd_pr__pfet_01v8 ad=3.988u pd=0.02074 as=3.988u ps=0.02074 w=400 l=60
X25 a_571150_0# a_571090_n50# a_561120_0# w_n120_n120# sky130_fd_pr__pfet_01v8 ad=3.988u pd=0.02074 as=3.988u ps=0.02074 w=400 l=60
X26 a_130270_0# a_130210_n50# a_120240_0# w_n120_n120# sky130_fd_pr__pfet_01v8 ad=3.988u pd=0.02074 as=3.988u ps=0.02074 w=400 l=60
X27 a_70150_0# a_70090_n50# a_60120_0# w_n120_n120# sky130_fd_pr__pfet_01v8 ad=3.988u pd=0.02074 as=3.988u ps=0.02074 w=400 l=60
X28 a_230470_0# a_230410_n50# a_220440_0# w_n120_n120# sky130_fd_pr__pfet_01v8 ad=3.988u pd=0.02074 as=3.988u ps=0.02074 w=400 l=60
X29 a_110230_0# a_110170_n50# a_100200_0# w_n120_n120# sky130_fd_pr__pfet_01v8 ad=3.988u pd=0.02074 as=3.988u ps=0.02074 w=400 l=60
X30 a_330670_0# a_330610_n50# a_320640_0# w_n120_n120# sky130_fd_pr__pfet_01v8 ad=3.988u pd=0.02074 as=3.988u ps=0.02074 w=400 l=60
X31 a_150310_0# a_150250_n50# a_140280_0# w_n120_n120# sky130_fd_pr__pfet_01v8 ad=3.988u pd=0.02074 as=3.988u ps=0.02074 w=400 l=60
.ends

.subckt XMNR SUB XMNR
X0 a_30070_0# a_30010_n50# a_20040_0# SUB sky130_fd_pr__nfet_01v8 ad=15.952u pd=0.02314 as=15.952u ps=0.02314 w=1600 l=60
X1 a_50110_0# a_50050_n50# a_40080_0# SUB sky130_fd_pr__nfet_01v8 ad=15.952u pd=0.02314 as=15.952u ps=0.02314 w=1600 l=60
X2 a_10030_0# a_9970_n50# a_0_0# SUB sky130_fd_pr__nfet_01v8 ad=15.952u pd=0.02314 as=15.952u ps=0.02314 w=1600 l=60
.ends

.subckt LNA_5T_CORE
XXMNL_0 VDDA SUB XMNL
XXMT_0 VDDA XMT
XXM1_0 XM1
XXM2_0 XM2
XXMNR_0 SUB VDDA XMNR
.ends
