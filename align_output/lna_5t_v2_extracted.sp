* SPICE3 file created from LNA_V2_F.ext - technology: sky130A

X0 a_n28059_n16073# a_n28059_n16073# a_n28059_n16073# w_n28121_n16309# sky130_fd_pr__pfet_01v8 ad=3.3 pd=20.33 as=649.75012 ps=8.59696k w=20 l=2
X1 a_n28059_n16073# a_n28059_n16073# a_n28059_n16073# w_n28121_n16309# sky130_fd_pr__pfet_01v8 ad=3.3 pd=20.33 as=0 ps=0 w=20 l=2
X2 a_n28059_n16073# a_n28059_n16073# a_n28059_n16073# w_n28121_n16309# sky130_fd_pr__pfet_01v8 ad=3.3 pd=20.33 as=0 ps=0 w=20 l=2
X3 a_n28059_n16073# a_n28059_n16073# a_n28059_n16073# w_n28121_n16309# sky130_fd_pr__pfet_01v8 ad=3.3 pd=20.33 as=0 ps=0 w=20 l=2
X4 a_n28059_n16073# a_n28059_n16073# a_n28059_n16073# w_n28121_n16309# sky130_fd_pr__pfet_01v8 ad=3.3 pd=20.33 as=0 ps=0 w=20 l=2
X5 a_n28059_n16073# a_n28059_n16073# a_n28059_n16073# w_n28121_n16309# sky130_fd_pr__pfet_01v8 ad=3.3 pd=20.33 as=0 ps=0 w=20 l=2
X6 a_n28059_n16073# a_n28059_n16073# a_n28059_n16073# w_n28121_n16309# sky130_fd_pr__pfet_01v8 ad=3.3 pd=20.33 as=0 ps=0 w=20 l=2
X7 a_n28059_n16073# a_n28059_n16073# a_n28059_n16073# w_n28121_n16309# sky130_fd_pr__pfet_01v8 ad=3.3 pd=20.33 as=0 ps=0 w=20 l=2
X8 a_n28059_n16073# a_n28059_n16073# a_n28059_n16073# w_n28121_n16309# sky130_fd_pr__pfet_01v8 ad=3.3 pd=20.33 as=0 ps=0 w=20 l=2
X9 a_n28059_n16073# a_n28059_n16073# a_n28059_n16073# w_n28121_n16309# sky130_fd_pr__pfet_01v8 ad=3.3 pd=20.33 as=0 ps=0 w=20 l=2
X10 a_n28059_n16073# a_n28059_n16073# a_n28059_n16073# w_n28121_n16309# sky130_fd_pr__pfet_01v8 ad=3.3 pd=20.33 as=0 ps=0 w=20 l=2
X11 a_n28059_n16073# a_n28059_n16073# a_n28059_n16073# w_n28121_n16309# sky130_fd_pr__pfet_01v8 ad=3.3 pd=20.33 as=0 ps=0 w=20 l=2
X12 a_n28059_n16073# a_n28059_n16073# a_n28059_n16073# w_n28121_n16309# sky130_fd_pr__pfet_01v8 ad=3.3 pd=20.33 as=0 ps=0 w=20 l=2
X13 a_n28059_n16073# a_n28059_n16073# a_n28059_n16073# w_n28121_n16309# sky130_fd_pr__pfet_01v8 ad=3.3 pd=20.33 as=0 ps=0 w=20 l=2
X14 a_n28059_n16073# a_n28059_n16073# a_n28059_n16073# w_n28121_n16309# sky130_fd_pr__pfet_01v8 ad=3.3 pd=20.33 as=0 ps=0 w=20 l=2
X15 a_n5350_n10000# a_n5272_n10196# a_n5350_n10000# VSUBS sky130_fd_pr__nfet_01v8 ad=0.0289 pd=0.68 as=103.4031 ps=999.28003 w=349.27499 l=0.17
X16 a_n28059_n16073# a_n28059_n16073# a_n28059_n16073# w_n28121_n16309# sky130_fd_pr__pfet_01v8 ad=3.3 pd=20.33 as=0 ps=0 w=20 l=2
X17 a_n28059_n16073# a_n28059_n16073# a_n28059_n16073# w_n28121_n16309# sky130_fd_pr__pfet_01v8 ad=3.3 pd=20.33 as=0 ps=0 w=20 l=2
X18 a_n28059_n16073# a_n28059_n16073# a_n28059_n16073# w_n28121_n16309# sky130_fd_pr__pfet_01v8 ad=3.3 pd=20.33 as=0 ps=0 w=20 l=2
X19 a_n28059_n16073# a_n28059_n16073# a_n28059_n16073# w_n28121_n16309# sky130_fd_pr__pfet_01v8 ad=3.3 pd=20.33 as=0 ps=0 w=20 l=2
X20 a_n28059_n16073# a_n28059_n16073# a_n28059_n16073# w_n28121_n16309# sky130_fd_pr__pfet_01v8 ad=3.3 pd=20.33 as=0 ps=0 w=20 l=2
X21 a_n28059_n16073# a_n28059_n16073# a_n28059_n16073# w_n28121_n16309# sky130_fd_pr__pfet_01v8 ad=3.3 pd=20.33 as=0 ps=0 w=20 l=2
X22 a_n28059_n16073# a_n28059_n16073# a_n28059_n16073# w_n28121_n16309# sky130_fd_pr__pfet_01v8 ad=3.3 pd=20.33 as=0 ps=0 w=20 l=2
X23 a_n28059_n16073# a_n28059_n16073# a_n28059_n16073# w_n28121_n16309# sky130_fd_pr__pfet_01v8 ad=3.3 pd=20.33 as=0 ps=0 w=20 l=2
X24 a_n28059_n16073# a_n28059_n16073# a_n28059_n16073# w_n28121_n16309# sky130_fd_pr__pfet_01v8 ad=3.3 pd=20.33 as=0 ps=0 w=20 l=2
X25 a_n28059_n16073# a_n28059_n16073# a_n28059_n16073# w_n28121_n16309# sky130_fd_pr__pfet_01v8 ad=3.3 pd=20.33 as=0 ps=0 w=20 l=2
X26 a_n28059_n16073# a_n28059_n16073# a_n28059_n16073# w_n28121_n16309# sky130_fd_pr__pfet_01v8 ad=3.3 pd=20.33 as=0 ps=0 w=20 l=2
X27 a_n28059_n16073# a_n28059_n16073# a_n28059_n16073# w_n28121_n16309# sky130_fd_pr__pfet_01v8 ad=3.3 pd=20.33 as=0 ps=0 w=20 l=2
X28 a_n28059_n16073# a_n28059_n16073# a_n28059_n16073# w_n28121_n16309# sky130_fd_pr__pfet_01v8 ad=3.3 pd=20.33 as=0 ps=0 w=20 l=2
X29 a_n28059_n16073# a_n28059_n16073# a_n28059_n16073# w_n28121_n16309# sky130_fd_pr__pfet_01v8 ad=3.3 pd=20.33 as=0 ps=0 w=20 l=2
X30 a_n28059_n16073# a_n28059_n16073# a_n28059_n16073# w_n28121_n16309# sky130_fd_pr__pfet_01v8 ad=3.3 pd=20.33 as=0 ps=0 w=20 l=2
X31 a_n28059_n16073# a_n28059_n16073# a_n28059_n16073# w_n28121_n16309# sky130_fd_pr__pfet_01v8 ad=3.3 pd=20.33 as=0 ps=0 w=20 l=2
X32 a_n28059_n16073# a_n28059_n16073# a_n28059_n16073# w_n28121_n16309# sky130_fd_pr__pfet_01v8 ad=7.8 pd=40.78 as=0 ps=0 w=20 l=2
X33 a_n28059_n16073# a_n28059_n16073# a_n28059_n16073# w_n28121_n16309# sky130_fd_pr__pfet_01v8 ad=3.3 pd=20.33 as=0 ps=0 w=20 l=2
X34 a_n28059_n16073# a_n28059_n16073# a_n28059_n16073# w_n28121_n16309# sky130_fd_pr__pfet_01v8 ad=3.3 pd=20.33 as=0 ps=0 w=20 l=2
X35 a_n28059_n16073# a_n28059_n16073# a_n28059_n16073# w_n28121_n16309# sky130_fd_pr__pfet_01v8 ad=0.0289 pd=0.68 as=0 ps=0 w=3.20799k l=0.17
X36 a_n28059_n16073# a_n28059_n16073# a_n28059_n16073# w_n28121_n16309# sky130_fd_pr__pfet_01v8 ad=3.3 pd=20.33 as=0 ps=0 w=20 l=2
X37 a_n28059_n16073# a_n28059_n16073# a_n28059_n16073# w_n28121_n16309# sky130_fd_pr__pfet_01v8 ad=3.3 pd=20.33 as=0 ps=0 w=20 l=2
X38 a_n28059_n16073# a_n28059_n16073# a_n28059_n16073# w_n28121_n16309# sky130_fd_pr__pfet_01v8 ad=3.3 pd=20.33 as=0 ps=0 w=20 l=2
X39 a_n28059_n16073# a_n28059_n16073# a_n28059_n16073# w_n28121_n16309# sky130_fd_pr__pfet_01v8 ad=3.3 pd=20.33 as=0 ps=0 w=20 l=2
X40 a_n28059_n16073# a_n28059_n16073# a_n28059_n16073# w_n28121_n16309# sky130_fd_pr__pfet_01v8 ad=3.3 pd=20.33 as=0 ps=0 w=20 l=2
X41 a_n28059_n16073# a_n28059_n16073# a_n28059_n16073# w_n28121_n16309# sky130_fd_pr__pfet_01v8 ad=3.3 pd=20.33 as=0 ps=0 w=20 l=2
X42 a_n28059_n16073# a_n28059_n16073# a_n28059_n16073# w_n28121_n16309# sky130_fd_pr__pfet_01v8 ad=3.3 pd=20.33 as=0 ps=0 w=20 l=2
X43 a_n28059_n16073# a_n28059_n16073# a_n28059_n16073# w_n28121_n16309# sky130_fd_pr__pfet_01v8 ad=3.3 pd=20.33 as=0 ps=0 w=20 l=2
X44 a_n28059_n16073# a_n28059_n16073# a_n28059_n16073# w_n28121_n16309# sky130_fd_pr__pfet_01v8 ad=3.3 pd=20.33 as=0 ps=0 w=20 l=2
X45 a_n28059_n16073# a_n28059_n16073# a_n28059_n16073# w_n28121_n16309# sky130_fd_pr__pfet_01v8 ad=3.3 pd=20.33 as=0 ps=0 w=20 l=2
X46 a_n28059_n16073# a_n28059_n16073# a_n28059_n16073# w_n28121_n16309# sky130_fd_pr__pfet_01v8 ad=3.3 pd=20.33 as=0 ps=0 w=20 l=2
X47 a_n28059_n16073# a_n28059_n16073# a_n28059_n16073# w_n28121_n16309# sky130_fd_pr__pfet_01v8 ad=3.3 pd=20.33 as=0 ps=0 w=20 l=2
C0 a_n5272_n10196# a_n5350_n10000# 0.12817p
C1 w_n28121_n16309# a_n28059_n16073# 46.457f
C2 a_n28059_n16073# VSUBS 57.0132f **FLOATING
C3 a_n5350_n10000# VSUBS 18.2734f **FLOATING
C4 a_n5272_n10196# VSUBS 8.6252f **FLOATING
C5 w_n28121_n16309# VSUBS 1.24838p **FLOATING
