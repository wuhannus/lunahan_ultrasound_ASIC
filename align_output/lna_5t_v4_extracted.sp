* SPICE3 file created from LNA_V4_F.ext - technology: sky130A

X0 w_n18946_n61982# a_n18607_n61742# w_n18946_n61982# w_n18946_n61982# sky130_fd_pr__pfet_01v8 ad=3.3 pd=20.33 as=2.829k ps=16.93954k w=20 l=2
X1 w_n18946_n61982# w_n18946_n61982# w_n18946_n61982# w_n18946_n61982# sky130_fd_pr__pfet_01v8 ad=16.5 pd=100.33 as=0 ps=0 w=100 l=2
X2 w_n18946_n61982# a_n18607_n61742# w_n18946_n61982# w_n18946_n61982# sky130_fd_pr__pfet_01v8 ad=3.3 pd=20.33 as=0 ps=0 w=20 l=2
X3 w_n18946_n61982# a_n18607_n61742# w_n18946_n61982# w_n18946_n61982# sky130_fd_pr__pfet_01v8 ad=3.3 pd=20.33 as=0 ps=0 w=20 l=2
X4 w_n18946_n61982# w_n18946_n61982# w_n18946_n61982# w_n18946_n61982# sky130_fd_pr__pfet_01v8 ad=16.5 pd=100.33 as=0 ps=0 w=100 l=2
X5 w_n18946_n61982# a_n18607_n61742# w_n18946_n61982# w_n18946_n61982# sky130_fd_pr__pfet_01v8 ad=3.3 pd=20.33 as=0 ps=0 w=20 l=2
X6 w_n18946_n61982# w_n18946_n61982# w_n18946_n61982# w_n18946_n61982# sky130_fd_pr__pfet_01v8 ad=16.5 pd=100.33 as=0 ps=0 w=100 l=2
X7 w_n18946_n61982# w_n18946_n61982# w_n18946_n61982# w_n18946_n61982# sky130_fd_pr__pfet_01v8 ad=16.5 pd=100.33 as=0 ps=0 w=100 l=2
X8 w_n18946_n61982# a_n18607_n61742# w_n18946_n61982# w_n18946_n61982# sky130_fd_pr__pfet_01v8 ad=3.3 pd=20.33 as=0 ps=0 w=20 l=2
X9 w_n18946_n61982# a_n18607_n61742# w_n18946_n61982# w_n18946_n61982# sky130_fd_pr__pfet_01v8 ad=3.3 pd=20.33 as=0 ps=0 w=20 l=2
X10 w_n18946_n61982# w_n18946_n61982# w_n18946_n61982# w_n18946_n61982# sky130_fd_pr__pfet_01v8 ad=16.5 pd=100.33 as=0 ps=0 w=100 l=2
X11 w_n18946_n61982# a_n18607_n61742# w_n18946_n61982# w_n18946_n61982# sky130_fd_pr__pfet_01v8 ad=3.3 pd=20.33 as=0 ps=0 w=20 l=2
X12 w_n18946_n61982# a_n18607_n61742# w_n18946_n61982# w_n18946_n61982# sky130_fd_pr__pfet_01v8 ad=3.3 pd=20.33 as=0 ps=0 w=20 l=2
X13 w_n18946_n61982# a_n18607_n61742# w_n18946_n61982# w_n18946_n61982# sky130_fd_pr__pfet_01v8 ad=3.3 pd=20.33 as=0 ps=0 w=20 l=2
X14 w_n18946_n61982# w_n18946_n61982# w_n18946_n61982# w_n18946_n61982# sky130_fd_pr__pfet_01v8 ad=16.5 pd=100.33 as=0 ps=0 w=100 l=2
X15 w_n18946_n61982# a_n18607_n61742# w_n18946_n61982# w_n18946_n61982# sky130_fd_pr__pfet_01v8 ad=3.3 pd=20.33 as=0 ps=0 w=20 l=2
X16 w_n18946_n61982# w_n18946_n61982# w_n18946_n61982# w_n18946_n61982# sky130_fd_pr__pfet_01v8 ad=16.5 pd=100.33 as=0 ps=0 w=100 l=2
X17 w_n18946_n61982# a_n18607_n61742# w_n18946_n61982# w_n18946_n61982# sky130_fd_pr__pfet_01v8 ad=3.3 pd=20.33 as=0 ps=0 w=20 l=2
X18 w_n18946_n61982# a_n18607_n61742# w_n18946_n61982# w_n18946_n61982# sky130_fd_pr__pfet_01v8 ad=7.8 pd=40.78 as=0 ps=0 w=20 l=2
X19 w_n18946_n61982# w_n18946_n61982# w_n18946_n61982# w_n18946_n61982# sky130_fd_pr__pfet_01v8 ad=16.5 pd=100.33 as=0 ps=0 w=100 l=2
X20 w_n18946_n61982# a_n18607_n61742# w_n18946_n61982# w_n18946_n61982# sky130_fd_pr__pfet_01v8 ad=3.3 pd=20.33 as=0 ps=0 w=20 l=2
X21 w_n18946_n61982# a_n18607_n61742# w_n18946_n61982# w_n18946_n61982# sky130_fd_pr__pfet_01v8 ad=3.3 pd=20.33 as=0 ps=0 w=20 l=2
X22 w_n18946_n61982# a_n18607_n61742# w_n18946_n61982# w_n18946_n61982# sky130_fd_pr__pfet_01v8 ad=3.3 pd=20.33 as=0 ps=0 w=20 l=2
X23 w_n18946_n61982# a_n18607_n61742# w_n18946_n61982# w_n18946_n61982# sky130_fd_pr__pfet_01v8 ad=3.3 pd=20.33 as=0 ps=0 w=20 l=2
X24 w_n18946_n61982# a_n18607_n61742# w_n18946_n61982# w_n18946_n61982# sky130_fd_pr__pfet_01v8 ad=3.3 pd=20.33 as=0 ps=0 w=20 l=2
X25 w_n18946_n61982# w_n18946_n61982# w_n18946_n61982# w_n18946_n61982# sky130_fd_pr__pfet_01v8 ad=16.5 pd=100.33 as=0 ps=0 w=100 l=2
X26 w_n18946_n61982# a_n18607_n61742# w_n18946_n61982# w_n18946_n61982# sky130_fd_pr__pfet_01v8 ad=3.3 pd=20.33 as=0 ps=0 w=20 l=2
X27 w_n18946_n61982# w_n18946_n61982# w_n18946_n61982# w_n18946_n61982# sky130_fd_pr__pfet_01v8 ad=16.5 pd=100.33 as=0 ps=0 w=100 l=2
X28 w_n18946_n61982# a_n18607_n61742# w_n18946_n61982# w_n18946_n61982# sky130_fd_pr__pfet_01v8 ad=3.3 pd=20.33 as=0 ps=0 w=20 l=2
X29 w_n18946_n61982# w_n18946_n61982# w_n18946_n61982# w_n18946_n61982# sky130_fd_pr__pfet_01v8 ad=16.5 pd=100.33 as=0 ps=0 w=100 l=2
X30 w_n18946_n61982# a_n18607_n61742# w_n18946_n61982# w_n18946_n61982# sky130_fd_pr__pfet_01v8 ad=3.3 pd=20.33 as=0 ps=0 w=20 l=2
X31 w_n18946_n61982# a_n18607_n61742# w_n18946_n61982# w_n18946_n61982# sky130_fd_pr__pfet_01v8 ad=3.3 pd=20.33 as=0 ps=0 w=20 l=2
X32 w_n18946_n61982# a_n18607_n61742# w_n18946_n61982# w_n18946_n61982# sky130_fd_pr__pfet_01v8 ad=3.3 pd=20.33 as=0 ps=0 w=20 l=2
X33 w_n18946_n61982# w_n18946_n61982# w_n18946_n61982# w_n18946_n61982# sky130_fd_pr__pfet_01v8 ad=16.5 pd=100.33 as=0 ps=0 w=100 l=2
X34 w_n18946_n61982# a_n18607_n61742# w_n18946_n61982# w_n18946_n61982# sky130_fd_pr__pfet_01v8 ad=3.3 pd=20.33 as=0 ps=0 w=20 l=2
X35 w_n18946_n61982# a_n18607_n61742# w_n18946_n61982# w_n18946_n61982# sky130_fd_pr__pfet_01v8 ad=3.3 pd=20.33 as=0 ps=0 w=20 l=2
X36 w_n18946_n61982# a_n18607_n61742# w_n18946_n61982# w_n18946_n61982# sky130_fd_pr__pfet_01v8 ad=3.3 pd=20.33 as=0 ps=0 w=20 l=2
X37 w_n18946_n61982# w_n18946_n61982# w_n18946_n61982# w_n18946_n61982# sky130_fd_pr__pfet_01v8 ad=16.5 pd=100.33 as=0 ps=0 w=100 l=2
X38 w_n18946_n61982# a_n18607_n61742# w_n18946_n61982# w_n18946_n61982# sky130_fd_pr__pfet_01v8 ad=3.3 pd=20.33 as=0 ps=0 w=20 l=2
X39 w_n18946_n61982# a_n18607_n61742# w_n18946_n61982# w_n18946_n61982# sky130_fd_pr__pfet_01v8 ad=3.3 pd=20.33 as=0 ps=0 w=20 l=2
X40 w_n18946_n61982# w_n18946_n61982# w_n18946_n61982# w_n18946_n61982# sky130_fd_pr__pfet_01v8 ad=16.5 pd=100.33 as=0 ps=0 w=100 l=2
X41 w_n18946_n61982# a_n18607_n61742# w_n18946_n61982# w_n18946_n61982# sky130_fd_pr__pfet_01v8 ad=3.3 pd=20.33 as=0 ps=0 w=20 l=2
X42 w_n18946_n61982# a_n18607_n61742# w_n18946_n61982# w_n18946_n61982# sky130_fd_pr__pfet_01v8 ad=3.3 pd=20.33 as=0 ps=0 w=20 l=2
X43 w_n18946_n61982# a_n18607_n61742# w_n18946_n61982# w_n18946_n61982# sky130_fd_pr__pfet_01v8 ad=3.3 pd=20.33 as=0 ps=0 w=20 l=2
X44 w_n18946_n61982# w_n18946_n61982# w_n18946_n61982# w_n18946_n61982# sky130_fd_pr__pfet_01v8 ad=16.5 pd=100.33 as=0 ps=0 w=100 l=2
X45 w_n18946_n61982# w_n18946_n61982# w_n18946_n61982# w_n18946_n61982# sky130_fd_pr__pfet_01v8 ad=16.5 pd=100.33 as=0 ps=0 w=100 l=2
X46 w_n18946_n61982# w_n18946_n61982# w_n18946_n61982# w_n18946_n61982# sky130_fd_pr__pfet_01v8 ad=16.5 pd=100.33 as=0 ps=0 w=100 l=2
X47 w_n18946_n61982# w_n18946_n61982# w_n18946_n61982# w_n18946_n61982# sky130_fd_pr__pfet_01v8 ad=16.5 pd=100.33 as=0 ps=0 w=100 l=2
X48 w_n18946_n61982# a_n18607_n61742# w_n18946_n61982# w_n18946_n61982# sky130_fd_pr__pfet_01v8 ad=3.3 pd=20.33 as=0 ps=0 w=20 l=2
X49 w_n18946_n61982# w_n18946_n61982# w_n18946_n61982# w_n18946_n61982# sky130_fd_pr__pfet_01v8 ad=16.5 pd=100.33 as=0 ps=0 w=100 l=2
X50 w_n18946_n61982# w_n18946_n61982# w_n18946_n61982# w_n18946_n61982# sky130_fd_pr__pfet_01v8 ad=16.5 pd=100.33 as=0 ps=0 w=100 l=2
X51 w_n18946_n61982# w_n18946_n61982# w_n18946_n61982# w_n18946_n61982# sky130_fd_pr__pfet_01v8 ad=16.5 pd=100.33 as=0 ps=0 w=100 l=2
X52 w_n18946_n61982# w_n18946_n61982# w_n18946_n61982# w_n18946_n61982# sky130_fd_pr__pfet_01v8 ad=16.5 pd=100.33 as=0 ps=0 w=100 l=2
X53 w_n18946_n61982# w_n18946_n61982# w_n18946_n61982# w_n18946_n61982# sky130_fd_pr__pfet_01v8 ad=16.5 pd=100.33 as=0 ps=0 w=100 l=2
X54 w_n18946_n61982# w_n18946_n61982# w_n18946_n61982# w_n18946_n61982# sky130_fd_pr__pfet_01v8 ad=16.5 pd=100.33 as=0 ps=0 w=100 l=2
X55 w_n18946_n61982# a_n18607_n61742# w_n18946_n61982# w_n18946_n61982# sky130_fd_pr__pfet_01v8 ad=3.3 pd=20.33 as=0 ps=0 w=20 l=2
X56 w_n18946_n61982# w_n18946_n61982# w_n18946_n61982# w_n18946_n61982# sky130_fd_pr__pfet_01v8 ad=16.5 pd=100.33 as=0 ps=0 w=100 l=2
X57 w_n18946_n61982# a_n18607_n61742# w_n18946_n61982# w_n18946_n61982# sky130_fd_pr__pfet_01v8 ad=3.3 pd=20.33 as=0 ps=0 w=20 l=2
X58 w_n18946_n61982# w_n18946_n61982# w_n18946_n61982# w_n18946_n61982# sky130_fd_pr__pfet_01v8 ad=16.5 pd=100.33 as=0 ps=0 w=100 l=2
X59 w_n18946_n61982# w_n18946_n61982# w_n18946_n61982# w_n18946_n61982# sky130_fd_pr__pfet_01v8 ad=16.5 pd=100.33 as=0 ps=0 w=100 l=2
X60 w_n18946_n61982# w_n18946_n61982# w_n18946_n61982# w_n18946_n61982# sky130_fd_pr__pfet_01v8 ad=16.5 pd=100.33 as=0 ps=0 w=100 l=2
X61 w_n18946_n61982# w_n18946_n61982# w_n18946_n61982# w_n18946_n61982# sky130_fd_pr__pfet_01v8 ad=16.5 pd=100.33 as=0 ps=0 w=100 l=2
X62 w_n18946_n61982# a_n18607_n61742# w_n18946_n61982# w_n18946_n61982# sky130_fd_pr__pfet_01v8 ad=3.3 pd=20.33 as=0 ps=0 w=20 l=2
X63 w_n18946_n61982# w_n18946_n61982# w_n18946_n61982# w_n18946_n61982# sky130_fd_pr__pfet_01v8 ad=16.5 pd=100.33 as=0 ps=0 w=100 l=2
X64 w_n18946_n61982# a_n18607_n61742# w_n18946_n61982# w_n18946_n61982# sky130_fd_pr__pfet_01v8 ad=3.3 pd=20.33 as=0 ps=0 w=20 l=2
X65 w_n18946_n61982# w_n18946_n61982# w_n18946_n61982# w_n18946_n61982# sky130_fd_pr__pfet_01v8 ad=16.5 pd=100.33 as=0 ps=0 w=100 l=2
X66 w_n18946_n61982# w_n18946_n61982# w_n18946_n61982# w_n18946_n61982# sky130_fd_pr__pfet_01v8 ad=39 pd=200.78 as=0 ps=0 w=100 l=2
X67 w_n18946_n61982# w_n18946_n61982# w_n18946_n61982# w_n18946_n61982# sky130_fd_pr__pfet_01v8 ad=16.5 pd=100.33 as=0 ps=0 w=100 l=2
X68 w_n18946_n61982# w_n18946_n61982# w_n18946_n61982# w_n18946_n61982# sky130_fd_pr__pfet_01v8 ad=16.5 pd=100.33 as=0 ps=0 w=100 l=2
X69 w_n18946_n61982# w_n18946_n61982# w_n18946_n61982# w_n18946_n61982# sky130_fd_pr__pfet_01v8 ad=16.5 pd=100.33 as=0 ps=0 w=100 l=2
X70 w_n18946_n61982# a_n18607_n61742# w_n18946_n61982# w_n18946_n61982# sky130_fd_pr__pfet_01v8 ad=3.3 pd=20.33 as=0 ps=0 w=20 l=2
X71 w_n18946_n61982# w_n18946_n61982# w_n18946_n61982# w_n18946_n61982# sky130_fd_pr__pfet_01v8 ad=16.5 pd=100.33 as=0 ps=0 w=100 l=2
X72 w_n18946_n61982# w_n18946_n61982# w_n18946_n61982# w_n18946_n61982# sky130_fd_pr__pfet_01v8 ad=16.5 pd=100.33 as=0 ps=0 w=100 l=2
X73 w_n18946_n61982# a_n18607_n61742# w_n18946_n61982# w_n18946_n61982# sky130_fd_pr__pfet_01v8 ad=3.3 pd=20.33 as=0 ps=0 w=20 l=2
X74 w_n18946_n61982# w_n18946_n61982# w_n18946_n61982# w_n18946_n61982# sky130_fd_pr__pfet_01v8 ad=16.5 pd=100.33 as=0 ps=0 w=100 l=2
X75 w_n18946_n61982# a_n18607_n61742# w_n18946_n61982# w_n18946_n61982# sky130_fd_pr__pfet_01v8 ad=3.3 pd=20.33 as=0 ps=0 w=20 l=2
X76 w_n18946_n61982# a_n18607_n61742# w_n18946_n61982# w_n18946_n61982# sky130_fd_pr__pfet_01v8 ad=3.3 pd=20.33 as=0 ps=0 w=20 l=2
X77 w_n18946_n61982# a_n18607_n61742# w_n18946_n61982# w_n18946_n61982# sky130_fd_pr__pfet_01v8 ad=3.3 pd=20.33 as=0 ps=0 w=20 l=2
X78 w_n18946_n61982# w_n18946_n61982# w_n18946_n61982# w_n18946_n61982# sky130_fd_pr__pfet_01v8 ad=16.5 pd=100.33 as=0 ps=0 w=100 l=2
X79 w_n18946_n61982# a_n18607_n61742# w_n18946_n61982# w_n18946_n61982# sky130_fd_pr__pfet_01v8 ad=3.3 pd=20.33 as=0 ps=0 w=20 l=2
X80 w_n18946_n61982# a_n18607_n61742# w_n18946_n61982# w_n18946_n61982# sky130_fd_pr__pfet_01v8 ad=3.3 pd=20.33 as=0 ps=0 w=20 l=2
X81 w_n18946_n61982# w_n18946_n61982# w_n18946_n61982# w_n18946_n61982# sky130_fd_pr__pfet_01v8 ad=16.5 pd=100.33 as=0 ps=0 w=100 l=2
X82 w_n18946_n61982# w_n18946_n61982# w_n18946_n61982# w_n18946_n61982# sky130_fd_pr__pfet_01v8 ad=39 pd=200.78 as=0 ps=0 w=100 l=2
X83 w_n18946_n61982# a_n18607_n61742# w_n18946_n61982# w_n18946_n61982# sky130_fd_pr__pfet_01v8 ad=3.3 pd=20.33 as=0 ps=0 w=20 l=2
X84 w_n18946_n61982# w_n18946_n61982# w_n18946_n61982# w_n18946_n61982# sky130_fd_pr__pfet_01v8 ad=16.5 pd=100.33 as=0 ps=0 w=100 l=2
X85 w_n18946_n61982# a_n18607_n61742# w_n18946_n61982# w_n18946_n61982# sky130_fd_pr__pfet_01v8 ad=3.3 pd=20.33 as=0 ps=0 w=20 l=2
X86 w_n18946_n61982# a_n18607_n61742# w_n18946_n61982# w_n18946_n61982# sky130_fd_pr__pfet_01v8 ad=3.3 pd=20.33 as=0 ps=0 w=20 l=2
X87 w_n18946_n61982# w_n18946_n61982# w_n18946_n61982# w_n18946_n61982# sky130_fd_pr__pfet_01v8 ad=16.5 pd=100.33 as=0 ps=0 w=100 l=2
X88 w_n18946_n61982# a_n18607_n61742# w_n18946_n61982# w_n18946_n61982# sky130_fd_pr__pfet_01v8 ad=3.3 pd=20.33 as=0 ps=0 w=20 l=2
X89 w_n18946_n61982# a_n18607_n61742# w_n18946_n61982# w_n18946_n61982# sky130_fd_pr__pfet_01v8 ad=3.3 pd=20.33 as=0 ps=0 w=20 l=2
X90 w_n18946_n61982# a_n18607_n61742# w_n18946_n61982# w_n18946_n61982# sky130_fd_pr__pfet_01v8 ad=3.3 pd=20.33 as=0 ps=0 w=20 l=2
X91 w_n18946_n61982# a_n18607_n61742# w_n18946_n61982# w_n18946_n61982# sky130_fd_pr__pfet_01v8 ad=3.3 pd=20.33 as=0 ps=0 w=20 l=2
X92 w_n18946_n61982# a_n18607_n61742# w_n18946_n61982# w_n18946_n61982# sky130_fd_pr__pfet_01v8 ad=3.3 pd=20.33 as=0 ps=0 w=20 l=2
X93 w_n18946_n61982# a_n18607_n61742# w_n18946_n61982# w_n18946_n61982# sky130_fd_pr__pfet_01v8 ad=3.3 pd=20.33 as=0 ps=0 w=20 l=2
X94 w_n18946_n61982# a_n18607_n61742# w_n18946_n61982# w_n18946_n61982# sky130_fd_pr__pfet_01v8 ad=3.3 pd=20.33 as=0 ps=0 w=20 l=2
X95 w_n18946_n61982# a_n18607_n61742# w_n18946_n61982# w_n18946_n61982# sky130_fd_pr__pfet_01v8 ad=3.3 pd=20.33 as=0 ps=0 w=20 l=2
X96 w_n18946_n61982# a_n18607_n61742# w_n18946_n61982# w_n18946_n61982# sky130_fd_pr__pfet_01v8 ad=3.3 pd=20.33 as=0 ps=0 w=20 l=2
X97 a_n5878_n10390# a_n5878_n10390# a_n5878_n10390# a_n5878_n10390# sky130_fd_pr__nfet_01v8 ad=39 pd=200.78 as=103.4031 ps=999.28003 w=100 l=3.08
X98 w_n18946_n61982# w_n18946_n61982# w_n18946_n61982# w_n18946_n61982# sky130_fd_pr__pfet_01v8 ad=39 pd=200.78 as=0 ps=0 w=100 l=2
X99 w_n18946_n61982# a_n18607_n61742# w_n18946_n61982# w_n18946_n61982# sky130_fd_pr__pfet_01v8 ad=3.3 pd=20.33 as=0 ps=0 w=20 l=2
X100 w_n18946_n61982# a_n18607_n61742# w_n18946_n61982# w_n18946_n61982# sky130_fd_pr__pfet_01v8 ad=3.3 pd=20.33 as=0 ps=0 w=20 l=2
X101 w_n18946_n61982# a_n18607_n61742# w_n18946_n61982# w_n18946_n61982# sky130_fd_pr__pfet_01v8 ad=3.3 pd=20.33 as=0 ps=0 w=20 l=2
X102 w_n18946_n61982# a_n18607_n61742# w_n18946_n61982# w_n18946_n61982# sky130_fd_pr__pfet_01v8 ad=3.3 pd=20.33 as=0 ps=0 w=20 l=2
X103 w_n18946_n61982# a_n18607_n61742# w_n18946_n61982# w_n18946_n61982# sky130_fd_pr__pfet_01v8 ad=3.3 pd=20.33 as=0 ps=0 w=20 l=2
X104 w_n18946_n61982# a_n18607_n61742# w_n18946_n61982# w_n18946_n61982# sky130_fd_pr__pfet_01v8 ad=3.3 pd=20.33 as=0 ps=0 w=20 l=2
X105 w_n18946_n61982# a_n18607_n61742# w_n18946_n61982# w_n18946_n61982# sky130_fd_pr__pfet_01v8 ad=3.3 pd=20.33 as=0 ps=0 w=20 l=2
X106 w_n18946_n61982# w_n18946_n61982# w_n18946_n61982# w_n18946_n61982# sky130_fd_pr__pfet_01v8 ad=16.5 pd=100.33 as=0 ps=0 w=100 l=2
X107 w_n18946_n61982# a_n18607_n61742# w_n18946_n61982# w_n18946_n61982# sky130_fd_pr__pfet_01v8 ad=3.3 pd=20.33 as=0 ps=0 w=20 l=2
X108 w_n18946_n61982# a_n18607_n61742# w_n18946_n61982# w_n18946_n61982# sky130_fd_pr__pfet_01v8 ad=3.3 pd=20.33 as=0 ps=0 w=20 l=2
X109 w_n18946_n61982# a_n18607_n61742# w_n18946_n61982# w_n18946_n61982# sky130_fd_pr__pfet_01v8 ad=3.3 pd=20.33 as=0 ps=0 w=20 l=2
X110 w_n18946_n61982# a_n18607_n61742# w_n18946_n61982# w_n18946_n61982# sky130_fd_pr__pfet_01v8 ad=3.3 pd=20.33 as=0 ps=0 w=20 l=2
X111 a_n5878_n10390# a_n5878_n10390# a_n5878_n10390# a_n5878_n10390# sky130_fd_pr__nfet_01v8 ad=0.0289 pd=0.68 as=0 ps=0 w=295.245 l=0.17
X112 w_n18946_n61982# w_n18946_n61982# w_n18946_n61982# w_n18946_n61982# sky130_fd_pr__pfet_01v8 ad=39 pd=200.78 as=0 ps=0 w=100 l=2
X113 w_n18946_n61982# a_n18607_n61742# w_n18946_n61982# w_n18946_n61982# sky130_fd_pr__pfet_01v8 ad=3.3 pd=20.33 as=0 ps=0 w=20 l=2
X114 w_n18946_n61982# a_n18607_n61742# w_n18946_n61982# w_n18946_n61982# sky130_fd_pr__pfet_01v8 ad=3.3 pd=20.33 as=0 ps=0 w=20 l=2
X115 w_n18946_n61982# w_n18946_n61982# w_n18946_n61982# w_n18946_n61982# sky130_fd_pr__pfet_01v8 ad=16.5 pd=100.33 as=0 ps=0 w=100 l=2
X116 w_n18946_n61982# w_n18946_n61982# w_n18946_n61982# w_n18946_n61982# sky130_fd_pr__pfet_01v8 ad=16.5 pd=100.33 as=0 ps=0 w=100 l=2
X117 w_n18946_n61982# w_n18946_n61982# w_n18946_n61982# w_n18946_n61982# sky130_fd_pr__pfet_01v8 ad=16.5 pd=100.33 as=0 ps=0 w=100 l=2
X118 w_n18946_n61982# a_n18607_n61742# w_n18946_n61982# w_n18946_n61982# sky130_fd_pr__pfet_01v8 ad=3.3 pd=20.33 as=0 ps=0 w=20 l=2
X119 w_n18946_n61982# w_n18946_n61982# w_n18946_n61982# w_n18946_n61982# sky130_fd_pr__pfet_01v8 ad=16.5 pd=100.33 as=0 ps=0 w=100 l=2
X120 w_n18946_n61982# a_n18607_n61742# w_n18946_n61982# w_n18946_n61982# sky130_fd_pr__pfet_01v8 ad=3.3 pd=20.33 as=0 ps=0 w=20 l=2
X121 w_n18946_n61982# a_n18607_n61742# w_n18946_n61982# w_n18946_n61982# sky130_fd_pr__pfet_01v8 ad=3.3 pd=20.33 as=0 ps=0 w=20 l=2
X122 w_n18946_n61982# a_n18607_n61742# w_n18946_n61982# w_n18946_n61982# sky130_fd_pr__pfet_01v8 ad=3.3 pd=20.33 as=0 ps=0 w=20 l=2
X123 w_n18946_n61982# w_n18946_n61982# w_n18946_n61982# w_n18946_n61982# sky130_fd_pr__pfet_01v8 ad=16.5 pd=100.33 as=0 ps=0 w=100 l=2
X124 w_n18946_n61982# w_n18946_n61982# w_n18946_n61982# w_n18946_n61982# sky130_fd_pr__pfet_01v8 ad=16.5 pd=100.33 as=0 ps=0 w=100 l=2
X125 w_n18946_n61982# a_n18607_n61742# w_n18946_n61982# w_n18946_n61982# sky130_fd_pr__pfet_01v8 ad=3.3 pd=20.33 as=0 ps=0 w=20 l=2
X126 w_n18946_n61982# w_n18946_n61982# w_n18946_n61982# w_n18946_n61982# sky130_fd_pr__pfet_01v8 ad=16.5 pd=100.33 as=0 ps=0 w=100 l=2
X127 w_n18946_n61982# w_n18946_n61982# w_n18946_n61982# w_n18946_n61982# sky130_fd_pr__pfet_01v8 ad=16.5 pd=100.33 as=0 ps=0 w=100 l=2
X128 w_n18946_n61982# w_n18946_n61982# w_n18946_n61982# w_n18946_n61982# sky130_fd_pr__pfet_01v8 ad=16.5 pd=100.33 as=0 ps=0 w=100 l=2
X129 w_n18946_n61982# a_n18607_n61742# w_n18946_n61982# w_n18946_n61982# sky130_fd_pr__pfet_01v8 ad=3.3 pd=20.33 as=0 ps=0 w=20 l=2
X130 w_n18946_n61982# a_n18607_n61742# w_n18946_n61982# w_n18946_n61982# sky130_fd_pr__pfet_01v8 ad=3.3 pd=20.33 as=0 ps=0 w=20 l=2
X131 w_n18946_n61982# w_n18946_n61982# w_n18946_n61982# w_n18946_n61982# sky130_fd_pr__pfet_01v8 ad=16.5 pd=100.33 as=0 ps=0 w=100 l=2
X132 w_n18946_n61982# w_n18946_n61982# w_n18946_n61982# w_n18946_n61982# sky130_fd_pr__pfet_01v8 ad=16.5 pd=100.33 as=0 ps=0 w=100 l=2
X133 w_n18946_n61982# a_n18607_n61742# w_n18946_n61982# w_n18946_n61982# sky130_fd_pr__pfet_01v8 ad=3.3 pd=20.33 as=0 ps=0 w=20 l=2
X134 w_n18946_n61982# w_n18946_n61982# w_n18946_n61982# w_n18946_n61982# sky130_fd_pr__pfet_01v8 ad=16.5 pd=100.33 as=0 ps=0 w=100 l=2
X135 w_n18946_n61982# a_n18607_n61742# w_n18946_n61982# w_n18946_n61982# sky130_fd_pr__pfet_01v8 ad=3.3 pd=20.33 as=0 ps=0 w=20 l=2
X136 w_n18946_n61982# w_n18946_n61982# w_n18946_n61982# w_n18946_n61982# sky130_fd_pr__pfet_01v8 ad=16.5 pd=100.33 as=0 ps=0 w=100 l=2
X137 w_n18946_n61982# a_n18607_n61742# w_n18946_n61982# w_n18946_n61982# sky130_fd_pr__pfet_01v8 ad=3.3 pd=20.33 as=0 ps=0 w=20 l=2
X138 w_n18946_n61982# w_n18946_n61982# w_n18946_n61982# w_n18946_n61982# sky130_fd_pr__pfet_01v8 ad=16.5 pd=100.33 as=0 ps=0 w=100 l=2
X139 w_n18946_n61982# w_n18946_n61982# w_n18946_n61982# w_n18946_n61982# sky130_fd_pr__pfet_01v8 ad=16.5 pd=100.33 as=0 ps=0 w=100 l=2
X140 w_n18946_n61982# w_n18946_n61982# w_n18946_n61982# w_n18946_n61982# sky130_fd_pr__pfet_01v8 ad=16.5 pd=100.33 as=0 ps=0 w=100 l=2
X141 w_n18946_n61982# w_n18946_n61982# w_n18946_n61982# w_n18946_n61982# sky130_fd_pr__pfet_01v8 ad=16.5 pd=100.33 as=0 ps=0 w=100 l=2
X142 w_n18946_n61982# a_n18607_n61742# w_n18946_n61982# w_n18946_n61982# sky130_fd_pr__pfet_01v8 ad=3.3 pd=20.33 as=0 ps=0 w=20 l=2
X143 w_n18946_n61982# w_n18946_n61982# w_n18946_n61982# w_n18946_n61982# sky130_fd_pr__pfet_01v8 ad=16.5 pd=100.33 as=0 ps=0 w=100 l=2
X144 w_n18946_n61982# a_n18607_n61742# w_n18946_n61982# w_n18946_n61982# sky130_fd_pr__pfet_01v8 ad=3.3 pd=20.33 as=0 ps=0 w=20 l=2
X145 w_n18946_n61982# a_n18607_n61742# w_n18946_n61982# w_n18946_n61982# sky130_fd_pr__pfet_01v8 ad=3.3 pd=20.33 as=0 ps=0 w=20 l=2
C0 w_n18946_n61982# a_n18607_n61742# 0.31747p
C1 a_n18607_n61742# a_n5878_n10390# 5.34853f **FLOATING
C2 w_n18946_n61982# a_n5878_n10390# 2.10498p **FLOATING
