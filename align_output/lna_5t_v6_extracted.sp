* SPICE3 file created from LNA_V6_F.ext - technology: sky130A

X0 TS a_n18607_n61742# w_n18946_n61982# w_n18946_n61982# sky130_fd_pr__pfet_01v8 ad=3.3 pd=20.33 as=3.3 ps=20.33 w=20 l=2
X1 OP GN TS w_n8184_n54710# sky130_fd_pr__pfet_01v8 ad=16.5 pd=100.33 as=16.5 ps=100.33 w=100 l=2
X2 TS a_n18607_n61742# w_n18946_n61982# w_n18946_n61982# sky130_fd_pr__pfet_01v8 ad=3.3 pd=20.33 as=3.3 ps=20.33 w=20 l=2
X3 w_n18946_n61982# a_n18607_n61742# TS w_n18946_n61982# sky130_fd_pr__pfet_01v8 ad=3.3 pd=20.33 as=3.3 ps=20.33 w=20 l=2
X4 OP GN TS w_n8184_n54710# sky130_fd_pr__pfet_01v8 ad=16.5 pd=100.33 as=16.5 ps=100.33 w=100 l=2
X5 TS a_n18607_n61742# w_n18946_n61982# w_n18946_n61982# sky130_fd_pr__pfet_01v8 ad=3.3 pd=20.33 as=3.3 ps=20.33 w=20 l=2
X6 TS GP OP w_n8184_n54710# sky130_fd_pr__pfet_01v8 ad=16.5 pd=100.33 as=16.5 ps=100.33 w=100 l=2
X7 TS GN OP w_n8184_n54710# sky130_fd_pr__pfet_01v8 ad=39 pd=200.78 as=16.5 ps=100.33 w=100 l=2
X8 TS a_n18607_n61742# w_n18946_n61982# w_n18946_n61982# sky130_fd_pr__pfet_01v8 ad=3.3 pd=20.33 as=3.3 ps=20.33 w=20 l=2
X9 w_n18946_n61982# a_n18607_n61742# TS w_n18946_n61982# sky130_fd_pr__pfet_01v8 ad=3.3 pd=20.33 as=3.3 ps=20.33 w=20 l=2
X10 TS GP OP w_n8184_n54710# sky130_fd_pr__pfet_01v8 ad=39 pd=200.78 as=16.5 ps=100.33 w=100 l=2
X11 w_n18946_n61982# a_n18607_n61742# TS w_n18946_n61982# sky130_fd_pr__pfet_01v8 ad=3.3 pd=20.33 as=3.3 ps=20.33 w=20 l=2
X12 TS a_n18607_n61742# w_n18946_n61982# w_n18946_n61982# sky130_fd_pr__pfet_01v8 ad=3.3 pd=20.33 as=3.3 ps=20.33 w=20 l=2
X13 w_n18946_n61982# a_n18607_n61742# TS w_n18946_n61982# sky130_fd_pr__pfet_01v8 ad=3.3 pd=20.33 as=3.3 ps=20.33 w=20 l=2
X14 OP GP TS w_n8184_n54710# sky130_fd_pr__pfet_01v8 ad=16.5 pd=100.33 as=16.5 ps=100.33 w=100 l=2
X15 TS a_n18607_n61742# w_n18946_n61982# w_n18946_n61982# sky130_fd_pr__pfet_01v8 ad=3.3 pd=20.33 as=3.3 ps=20.33 w=20 l=2
X16 OP GP TS w_n8184_n54710# sky130_fd_pr__pfet_01v8 ad=16.5 pd=100.33 as=16.5 ps=100.33 w=100 l=2
X17 w_n18946_n61982# a_n18607_n61742# TS w_n18946_n61982# sky130_fd_pr__pfet_01v8 ad=3.3 pd=20.33 as=3.3 ps=20.33 w=20 l=2
X18 TS a_n18607_n61742# w_n18946_n61982# w_n18946_n61982# sky130_fd_pr__pfet_01v8 ad=3.3 pd=20.33 as=7.8 ps=40.78 w=20 l=2
X19 TS GN OP w_n8184_n54710# sky130_fd_pr__pfet_01v8 ad=16.5 pd=100.33 as=16.5 ps=100.33 w=100 l=2
X20 TS a_n18607_n61742# w_n18946_n61982# w_n18946_n61982# sky130_fd_pr__pfet_01v8 ad=3.3 pd=20.33 as=3.3 ps=20.33 w=20 l=2
X21 w_n18946_n61982# a_n18607_n61742# TS w_n18946_n61982# sky130_fd_pr__pfet_01v8 ad=3.3 pd=20.33 as=3.3 ps=20.33 w=20 l=2
X22 w_n18946_n61982# a_n18607_n61742# TS w_n18946_n61982# sky130_fd_pr__pfet_01v8 ad=3.3 pd=20.33 as=3.3 ps=20.33 w=20 l=2
X23 w_n18946_n61982# a_n18607_n61742# TS w_n18946_n61982# sky130_fd_pr__pfet_01v8 ad=3.3 pd=20.33 as=3.3 ps=20.33 w=20 l=2
X24 TS a_n18607_n61742# w_n18946_n61982# w_n18946_n61982# sky130_fd_pr__pfet_01v8 ad=3.3 pd=20.33 as=3.3 ps=20.33 w=20 l=2
X25 OP GN TS w_n8184_n54710# sky130_fd_pr__pfet_01v8 ad=16.5 pd=100.33 as=16.5 ps=100.33 w=100 l=2
X26 TS a_n18607_n61742# w_n18946_n61982# w_n18946_n61982# sky130_fd_pr__pfet_01v8 ad=3.3 pd=20.33 as=3.3 ps=20.33 w=20 l=2
X27 OP GN TS w_n8184_n54710# sky130_fd_pr__pfet_01v8 ad=16.5 pd=100.33 as=16.5 ps=100.33 w=100 l=2
X28 w_n18946_n61982# a_n18607_n61742# TS w_n18946_n61982# sky130_fd_pr__pfet_01v8 ad=3.3 pd=20.33 as=3.3 ps=20.33 w=20 l=2
X29 OP GN TS w_n8184_n54710# sky130_fd_pr__pfet_01v8 ad=16.5 pd=100.33 as=16.5 ps=100.33 w=100 l=2
X30 w_n18946_n61982# a_n18607_n61742# TS w_n18946_n61982# sky130_fd_pr__pfet_01v8 ad=3.3 pd=20.33 as=3.3 ps=20.33 w=20 l=2
X31 w_n18946_n61982# a_n18607_n61742# TS w_n18946_n61982# sky130_fd_pr__pfet_01v8 ad=3.3 pd=20.33 as=3.3 ps=20.33 w=20 l=2
X32 w_n18946_n61982# a_n18607_n61742# TS w_n18946_n61982# sky130_fd_pr__pfet_01v8 ad=3.3 pd=20.33 as=3.3 ps=20.33 w=20 l=2
X33 TS GN OP w_n8184_n54710# sky130_fd_pr__pfet_01v8 ad=16.5 pd=100.33 as=16.5 ps=100.33 w=100 l=2
X34 TS a_n18607_n61742# w_n18946_n61982# w_n18946_n61982# sky130_fd_pr__pfet_01v8 ad=3.3 pd=20.33 as=3.3 ps=20.33 w=20 l=2
X35 w_n18946_n61982# a_n18607_n61742# TS w_n18946_n61982# sky130_fd_pr__pfet_01v8 ad=3.3 pd=20.33 as=3.3 ps=20.33 w=20 l=2
X36 TS a_n18607_n61742# w_n18946_n61982# w_n18946_n61982# sky130_fd_pr__pfet_01v8 ad=3.3 pd=20.33 as=3.3 ps=20.33 w=20 l=2
X37 OP GP TS w_n8184_n54710# sky130_fd_pr__pfet_01v8 ad=16.5 pd=100.33 as=16.5 ps=100.33 w=100 l=2
X38 TS a_n18607_n61742# w_n18946_n61982# w_n18946_n61982# sky130_fd_pr__pfet_01v8 ad=3.3 pd=20.33 as=3.3 ps=20.33 w=20 l=2
X39 w_n18946_n61982# a_n18607_n61742# TS w_n18946_n61982# sky130_fd_pr__pfet_01v8 ad=3.3 pd=20.33 as=3.3 ps=20.33 w=20 l=2
X40 OP GP TS w_n8184_n54710# sky130_fd_pr__pfet_01v8 ad=16.5 pd=100.33 as=16.5 ps=100.33 w=100 l=2
X41 TS a_n18607_n61742# w_n18946_n61982# w_n18946_n61982# sky130_fd_pr__pfet_01v8 ad=3.3 pd=20.33 as=3.3 ps=20.33 w=20 l=2
X42 w_n18946_n61982# a_n18607_n61742# TS w_n18946_n61982# sky130_fd_pr__pfet_01v8 ad=3.3 pd=20.33 as=3.3 ps=20.33 w=20 l=2
X43 TS a_n18607_n61742# w_n18946_n61982# w_n18946_n61982# sky130_fd_pr__pfet_01v8 ad=3.3 pd=20.33 as=3.3 ps=20.33 w=20 l=2
X44 OP GP TS w_n8184_n54710# sky130_fd_pr__pfet_01v8 ad=16.5 pd=100.33 as=16.5 ps=100.33 w=100 l=2
X45 OP GN TS w_n8184_n54710# sky130_fd_pr__pfet_01v8 ad=16.5 pd=100.33 as=16.5 ps=100.33 w=100 l=2
X46 OP GP TS w_n8184_n54710# sky130_fd_pr__pfet_01v8 ad=16.5 pd=100.33 as=16.5 ps=100.33 w=100 l=2
X47 TS GP OP w_n8184_n54710# sky130_fd_pr__pfet_01v8 ad=16.5 pd=100.33 as=16.5 ps=100.33 w=100 l=2
X48 w_n18946_n61982# a_n18607_n61742# TS w_n18946_n61982# sky130_fd_pr__pfet_01v8 ad=3.3 pd=20.33 as=3.3 ps=20.33 w=20 l=2
X49 TS GN OP w_n8184_n54710# sky130_fd_pr__pfet_01v8 ad=16.5 pd=100.33 as=16.5 ps=100.33 w=100 l=2
X50 TS GP OP w_n8184_n54710# sky130_fd_pr__pfet_01v8 ad=16.5 pd=100.33 as=16.5 ps=100.33 w=100 l=2
X51 OP GN TS w_n8184_n54710# sky130_fd_pr__pfet_01v8 ad=16.5 pd=100.33 as=16.5 ps=100.33 w=100 l=2
X52 OP GN TS w_n8184_n54710# sky130_fd_pr__pfet_01v8 ad=16.5 pd=100.33 as=16.5 ps=100.33 w=100 l=2
X53 OP GP TS w_n8184_n54710# sky130_fd_pr__pfet_01v8 ad=16.5 pd=100.33 as=16.5 ps=100.33 w=100 l=2
X54 OP GN TS w_n8184_n54710# sky130_fd_pr__pfet_01v8 ad=16.5 pd=100.33 as=16.5 ps=100.33 w=100 l=2
X55 TS a_n18607_n61742# w_n18946_n61982# w_n18946_n61982# sky130_fd_pr__pfet_01v8 ad=3.3 pd=20.33 as=3.3 ps=20.33 w=20 l=2
X56 TS GN OP w_n8184_n54710# sky130_fd_pr__pfet_01v8 ad=16.5 pd=100.33 as=16.5 ps=100.33 w=100 l=2
X57 TS a_n18607_n61742# w_n18946_n61982# w_n18946_n61982# sky130_fd_pr__pfet_01v8 ad=3.3 pd=20.33 as=3.3 ps=20.33 w=20 l=2
X58 OP GP TS w_n8184_n54710# sky130_fd_pr__pfet_01v8 ad=16.5 pd=100.33 as=16.5 ps=100.33 w=100 l=2
X59 TS GN OP w_n8184_n54710# sky130_fd_pr__pfet_01v8 ad=16.5 pd=100.33 as=16.5 ps=100.33 w=100 l=2
X60 TS GN OP w_n8184_n54710# sky130_fd_pr__pfet_01v8 ad=16.5 pd=100.33 as=16.5 ps=100.33 w=100 l=2
X61 TS GP OP w_n8184_n54710# sky130_fd_pr__pfet_01v8 ad=16.5 pd=100.33 as=16.5 ps=100.33 w=100 l=2
X62 TS a_n18607_n61742# w_n18946_n61982# w_n18946_n61982# sky130_fd_pr__pfet_01v8 ad=3.3 pd=20.33 as=3.3 ps=20.33 w=20 l=2
X63 OP GP TS w_n8184_n54710# sky130_fd_pr__pfet_01v8 ad=16.5 pd=100.33 as=16.5 ps=100.33 w=100 l=2
X64 w_n18946_n61982# a_n18607_n61742# TS w_n18946_n61982# sky130_fd_pr__pfet_01v8 ad=3.3 pd=20.33 as=3.3 ps=20.33 w=20 l=2
X65 TS GP OP w_n8184_n54710# sky130_fd_pr__pfet_01v8 ad=16.5 pd=100.33 as=16.5 ps=100.33 w=100 l=2
X66 OP GN TS w_n8184_n54710# sky130_fd_pr__pfet_01v8 ad=16.5 pd=100.33 as=39 ps=200.78 w=100 l=2
X67 OP GP TS w_n8184_n54710# sky130_fd_pr__pfet_01v8 ad=16.5 pd=100.33 as=16.5 ps=100.33 w=100 l=2
X68 TS GP OP w_n8184_n54710# sky130_fd_pr__pfet_01v8 ad=16.5 pd=100.33 as=16.5 ps=100.33 w=100 l=2
X69 OP GN TS w_n8184_n54710# sky130_fd_pr__pfet_01v8 ad=16.5 pd=100.33 as=16.5 ps=100.33 w=100 l=2
X70 w_n18946_n61982# a_n18607_n61742# TS w_n18946_n61982# sky130_fd_pr__pfet_01v8 ad=3.3 pd=20.33 as=3.3 ps=20.33 w=20 l=2
X71 TS GP OP w_n8184_n54710# sky130_fd_pr__pfet_01v8 ad=16.5 pd=100.33 as=16.5 ps=100.33 w=100 l=2
X72 TS GP OP w_n8184_n54710# sky130_fd_pr__pfet_01v8 ad=16.5 pd=100.33 as=16.5 ps=100.33 w=100 l=2
X73 w_n18946_n61982# a_n18607_n61742# TS w_n18946_n61982# sky130_fd_pr__pfet_01v8 ad=3.3 pd=20.33 as=3.3 ps=20.33 w=20 l=2
X74 TS GP OP w_n8184_n54710# sky130_fd_pr__pfet_01v8 ad=16.5 pd=100.33 as=16.5 ps=100.33 w=100 l=2
X75 w_n18946_n61982# a_n18607_n61742# TS w_n18946_n61982# sky130_fd_pr__pfet_01v8 ad=3.3 pd=20.33 as=3.3 ps=20.33 w=20 l=2
X76 TS a_n18607_n61742# w_n18946_n61982# w_n18946_n61982# sky130_fd_pr__pfet_01v8 ad=3.3 pd=20.33 as=3.3 ps=20.33 w=20 l=2
X77 TS a_n18607_n61742# w_n18946_n61982# w_n18946_n61982# sky130_fd_pr__pfet_01v8 ad=3.3 pd=20.33 as=3.3 ps=20.33 w=20 l=2
X78 OP GN TS w_n8184_n54710# sky130_fd_pr__pfet_01v8 ad=16.5 pd=100.33 as=16.5 ps=100.33 w=100 l=2
X79 w_n18946_n61982# a_n18607_n61742# TS w_n18946_n61982# sky130_fd_pr__pfet_01v8 ad=3.3 pd=20.33 as=3.3 ps=20.33 w=20 l=2
X80 TS a_n18607_n61742# w_n18946_n61982# w_n18946_n61982# sky130_fd_pr__pfet_01v8 ad=3.3 pd=20.33 as=3.3 ps=20.33 w=20 l=2
X81 TS GN OP w_n8184_n54710# sky130_fd_pr__pfet_01v8 ad=16.5 pd=100.33 as=16.5 ps=100.33 w=100 l=2
X82 OP GP TS w_n8184_n54710# sky130_fd_pr__pfet_01v8 ad=16.5 pd=100.33 as=39 ps=200.78 w=100 l=2
X83 w_n18946_n61982# a_n18607_n61742# TS w_n18946_n61982# sky130_fd_pr__pfet_01v8 ad=3.3 pd=20.33 as=3.3 ps=20.33 w=20 l=2
X84 TS GN OP w_n8184_n54710# sky130_fd_pr__pfet_01v8 ad=16.5 pd=100.33 as=16.5 ps=100.33 w=100 l=2
X85 TS a_n18607_n61742# w_n18946_n61982# w_n18946_n61982# sky130_fd_pr__pfet_01v8 ad=3.3 pd=20.33 as=3.3 ps=20.33 w=20 l=2
X86 w_n18946_n61982# a_n18607_n61742# TS w_n18946_n61982# sky130_fd_pr__pfet_01v8 ad=3.3 pd=20.33 as=3.3 ps=20.33 w=20 l=2
X87 TS GN OP w_n8184_n54710# sky130_fd_pr__pfet_01v8 ad=16.5 pd=100.33 as=16.5 ps=100.33 w=100 l=2
X88 w_n18946_n61982# a_n18607_n61742# TS w_n18946_n61982# sky130_fd_pr__pfet_01v8 ad=3.3 pd=20.33 as=3.3 ps=20.33 w=20 l=2
X89 w_n18946_n61982# a_n18607_n61742# TS w_n18946_n61982# sky130_fd_pr__pfet_01v8 ad=3.3 pd=20.33 as=3.3 ps=20.33 w=20 l=2
X90 w_n18946_n61982# a_n18607_n61742# TS w_n18946_n61982# sky130_fd_pr__pfet_01v8 ad=3.3 pd=20.33 as=3.3 ps=20.33 w=20 l=2
X91 TS a_n18607_n61742# w_n18946_n61982# w_n18946_n61982# sky130_fd_pr__pfet_01v8 ad=3.3 pd=20.33 as=3.3 ps=20.33 w=20 l=2
X92 TS a_n18607_n61742# w_n18946_n61982# w_n18946_n61982# sky130_fd_pr__pfet_01v8 ad=3.3 pd=20.33 as=3.3 ps=20.33 w=20 l=2
X93 w_n18946_n61982# a_n18607_n61742# TS w_n18946_n61982# sky130_fd_pr__pfet_01v8 ad=3.3 pd=20.33 as=3.3 ps=20.33 w=20 l=2
X94 TS a_n18607_n61742# w_n18946_n61982# w_n18946_n61982# sky130_fd_pr__pfet_01v8 ad=3.3 pd=20.33 as=3.3 ps=20.33 w=20 l=2
X95 TS a_n18607_n61742# w_n18946_n61982# w_n18946_n61982# sky130_fd_pr__pfet_01v8 ad=3.3 pd=20.33 as=3.3 ps=20.33 w=20 l=2
X96 w_n18946_n61982# a_n18607_n61742# TS w_n18946_n61982# sky130_fd_pr__pfet_01v8 ad=3.3 pd=20.33 as=3.3 ps=20.33 w=20 l=2
X97 OP GP TS w_n8184_n54710# sky130_fd_pr__pfet_01v8 ad=16.5 pd=100.33 as=39 ps=200.78 w=100 l=2
X98 TS a_n18607_n61742# w_n18946_n61982# w_n18946_n61982# sky130_fd_pr__pfet_01v8 ad=3.3 pd=20.33 as=3.3 ps=20.33 w=20 l=2
X99 w_n18946_n61982# a_n18607_n61742# TS w_n18946_n61982# sky130_fd_pr__pfet_01v8 ad=3.3 pd=20.33 as=3.3 ps=20.33 w=20 l=2
X100 TS a_n18607_n61742# w_n18946_n61982# w_n18946_n61982# sky130_fd_pr__pfet_01v8 ad=3.3 pd=20.33 as=3.3 ps=20.33 w=20 l=2
X101 w_n18946_n61982# a_n18607_n61742# TS w_n18946_n61982# sky130_fd_pr__pfet_01v8 ad=3.3 pd=20.33 as=3.3 ps=20.33 w=20 l=2
X102 TS a_n18607_n61742# w_n18946_n61982# w_n18946_n61982# sky130_fd_pr__pfet_01v8 ad=3.3 pd=20.33 as=3.3 ps=20.33 w=20 l=2
X103 w_n18946_n61982# a_n18607_n61742# TS w_n18946_n61982# sky130_fd_pr__pfet_01v8 ad=3.3 pd=20.33 as=3.3 ps=20.33 w=20 l=2
X104 w_n18946_n61982# a_n18607_n61742# TS w_n18946_n61982# sky130_fd_pr__pfet_01v8 ad=3.3 pd=20.33 as=3.3 ps=20.33 w=20 l=2
X105 TS GN OP w_n8184_n54710# sky130_fd_pr__pfet_01v8 ad=16.5 pd=100.33 as=16.5 ps=100.33 w=100 l=2
X106 TS a_n18607_n61742# w_n18946_n61982# w_n18946_n61982# sky130_fd_pr__pfet_01v8 ad=3.3 pd=20.33 as=3.3 ps=20.33 w=20 l=2
X107 TS a_n18607_n61742# w_n18946_n61982# w_n18946_n61982# sky130_fd_pr__pfet_01v8 ad=3.3 pd=20.33 as=3.3 ps=20.33 w=20 l=2
X108 w_n18946_n61982# a_n18607_n61742# TS w_n18946_n61982# sky130_fd_pr__pfet_01v8 ad=3.3 pd=20.33 as=3.3 ps=20.33 w=20 l=2
X109 w_n18946_n61982# a_n18607_n61742# TS w_n18946_n61982# sky130_fd_pr__pfet_01v8 ad=3.3 pd=20.33 as=3.3 ps=20.33 w=20 l=2
X110 OP OP OP OP sky130_fd_pr__nfet_01v8 ad=39 pd=200.78 as=103.4031 ps=999.28003 w=100 l=3.08
X111 OP GN TS w_n8184_n54710# sky130_fd_pr__pfet_01v8 ad=16.5 pd=100.33 as=39 ps=200.78 w=100 l=2
X112 TS a_n18607_n61742# w_n18946_n61982# w_n18946_n61982# sky130_fd_pr__pfet_01v8 ad=3.3 pd=20.33 as=3.3 ps=20.33 w=20 l=2
X113 w_n18946_n61982# a_n18607_n61742# TS w_n18946_n61982# sky130_fd_pr__pfet_01v8 ad=3.3 pd=20.33 as=3.3 ps=20.33 w=20 l=2
X114 OP GN TS w_n8184_n54710# sky130_fd_pr__pfet_01v8 ad=16.5 pd=100.33 as=16.5 ps=100.33 w=100 l=2
X115 TS GN OP w_n8184_n54710# sky130_fd_pr__pfet_01v8 ad=16.5 pd=100.33 as=16.5 ps=100.33 w=100 l=2
X116 TS GP OP w_n8184_n54710# sky130_fd_pr__pfet_01v8 ad=16.5 pd=100.33 as=16.5 ps=100.33 w=100 l=2
X117 TS a_n18607_n61742# w_n18946_n61982# w_n18946_n61982# sky130_fd_pr__pfet_01v8 ad=3.3 pd=20.33 as=3.3 ps=20.33 w=20 l=2
X118 TS GP OP w_n8184_n54710# sky130_fd_pr__pfet_01v8 ad=16.5 pd=100.33 as=16.5 ps=100.33 w=100 l=2
X119 TS a_n18607_n61742# w_n18946_n61982# w_n18946_n61982# sky130_fd_pr__pfet_01v8 ad=3.3 pd=20.33 as=3.3 ps=20.33 w=20 l=2
X120 TS a_n18607_n61742# w_n18946_n61982# w_n18946_n61982# sky130_fd_pr__pfet_01v8 ad=3.3 pd=20.33 as=3.3 ps=20.33 w=20 l=2
X121 TS a_n18607_n61742# w_n18946_n61982# w_n18946_n61982# sky130_fd_pr__pfet_01v8 ad=3.3 pd=20.33 as=3.3 ps=20.33 w=20 l=2
X122 OP GN TS w_n8184_n54710# sky130_fd_pr__pfet_01v8 ad=16.5 pd=100.33 as=16.5 ps=100.33 w=100 l=2
X123 TS GP OP w_n8184_n54710# sky130_fd_pr__pfet_01v8 ad=16.5 pd=100.33 as=16.5 ps=100.33 w=100 l=2
X124 TS a_n18607_n61742# w_n18946_n61982# w_n18946_n61982# sky130_fd_pr__pfet_01v8 ad=3.3 pd=20.33 as=3.3 ps=20.33 w=20 l=2
X125 TS GN OP w_n8184_n54710# sky130_fd_pr__pfet_01v8 ad=16.5 pd=100.33 as=16.5 ps=100.33 w=100 l=2
X126 OP GP TS w_n8184_n54710# sky130_fd_pr__pfet_01v8 ad=16.5 pd=100.33 as=16.5 ps=100.33 w=100 l=2
X127 TS GP OP w_n8184_n54710# sky130_fd_pr__pfet_01v8 ad=16.5 pd=100.33 as=16.5 ps=100.33 w=100 l=2
X128 TS a_n18607_n61742# w_n18946_n61982# w_n18946_n61982# sky130_fd_pr__pfet_01v8 ad=3.3 pd=20.33 as=3.3 ps=20.33 w=20 l=2
X129 w_n18946_n61982# a_n18607_n61742# TS w_n18946_n61982# sky130_fd_pr__pfet_01v8 ad=3.3 pd=20.33 as=3.3 ps=20.33 w=20 l=2
X130 OP OP OP OP sky130_fd_pr__nfet_01v8 ad=0.0289 pd=0.68 as=0 ps=0 w=225.88 l=0.17
X131 TS GN OP w_n8184_n54710# sky130_fd_pr__pfet_01v8 ad=16.5 pd=100.33 as=16.5 ps=100.33 w=100 l=2
X132 OP GP TS w_n8184_n54710# sky130_fd_pr__pfet_01v8 ad=16.5 pd=100.33 as=16.5 ps=100.33 w=100 l=2
X133 w_n18946_n61982# a_n18607_n61742# TS w_n18946_n61982# sky130_fd_pr__pfet_01v8 ad=7.8 pd=40.78 as=3.3 ps=20.33 w=20 l=2
X134 OP GP TS w_n8184_n54710# sky130_fd_pr__pfet_01v8 ad=16.5 pd=100.33 as=16.5 ps=100.33 w=100 l=2
X135 w_n18946_n61982# a_n18607_n61742# TS w_n18946_n61982# sky130_fd_pr__pfet_01v8 ad=3.3 pd=20.33 as=3.3 ps=20.33 w=20 l=2
X136 OP GP TS w_n8184_n54710# sky130_fd_pr__pfet_01v8 ad=16.5 pd=100.33 as=16.5 ps=100.33 w=100 l=2
X137 w_n18946_n61982# a_n18607_n61742# TS w_n18946_n61982# sky130_fd_pr__pfet_01v8 ad=3.3 pd=20.33 as=3.3 ps=20.33 w=20 l=2
X138 TS GN OP w_n8184_n54710# sky130_fd_pr__pfet_01v8 ad=16.5 pd=100.33 as=16.5 ps=100.33 w=100 l=2
X139 TS GP OP w_n8184_n54710# sky130_fd_pr__pfet_01v8 ad=39 pd=200.78 as=16.5 ps=100.33 w=100 l=2
X140 TS GP OP w_n8184_n54710# sky130_fd_pr__pfet_01v8 ad=16.5 pd=100.33 as=16.5 ps=100.33 w=100 l=2
X141 TS GN OP w_n8184_n54710# sky130_fd_pr__pfet_01v8 ad=39 pd=200.78 as=16.5 ps=100.33 w=100 l=2
X142 TS a_n18607_n61742# w_n18946_n61982# w_n18946_n61982# sky130_fd_pr__pfet_01v8 ad=3.3 pd=20.33 as=3.3 ps=20.33 w=20 l=2
X143 OP GN TS w_n8184_n54710# sky130_fd_pr__pfet_01v8 ad=16.5 pd=100.33 as=16.5 ps=100.33 w=100 l=2
X144 w_n18946_n61982# a_n18607_n61742# TS w_n18946_n61982# sky130_fd_pr__pfet_01v8 ad=3.3 pd=20.33 as=3.3 ps=20.33 w=20 l=2
X145 TS a_n18607_n61742# w_n18946_n61982# w_n18946_n61982# sky130_fd_pr__pfet_01v8 ad=3.3 pd=20.33 as=3.3 ps=20.33 w=20 l=2
C0 GP TS 0.24708p
C1 w_n18946_n61982# a_n18607_n61742# 0.19501p
C2 w_n18946_n61982# TS 93.9623f
C3 GP GN 29.2543f
C4 w_n8184_n54710# TS 37.8829f
C5 w_n8184_n54710# GN 23.5487f
C6 w_n8184_n54710# GP 23.8178f
C7 TS a_n18607_n61742# 0.1216p
C8 GN TS 0.24703p
C9 a_n18607_n61742# OP 5.34853f **FLOATING
C10 TS OP 0.25435p **FLOATING
C11 GN OP 0.2573p **FLOATING
C12 GP OP 0.26014p **FLOATING
C13 w_n18946_n61982# OP 0.49901p **FLOATING
C14 w_n8184_n54710# OP 2.07031p **FLOATING
