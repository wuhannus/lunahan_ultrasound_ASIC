* SPICE3 file created from LNA_V7_F.ext - technology: sky130A

X0 OP GP TS w_n8184_n54494# sky130_fd_pr__pfet_01v8 ad=16.5 pd=100.33 as=16.5 ps=100.33 w=100 l=2
X1 TS GN ON w_n8184_n54494# sky130_fd_pr__pfet_01v8 ad=16.5 pd=100.33 as=16.5 ps=100.33 w=100 l=2
X2 TS GN ON w_n8184_n54494# sky130_fd_pr__pfet_01v8 ad=16.5 pd=100.33 as=16.5 ps=100.33 w=100 l=2
X3 a_n18207_n61330# a_n18607_n61526# a_n18685_n61330# w_n18946_n61766# sky130_fd_pr__pfet_01v8 ad=3.3 pd=20.33 as=3.3 ps=20.33 w=20 l=2
X4 OP GP TS w_n8184_n54494# sky130_fd_pr__pfet_01v8 ad=16.5 pd=100.33 as=16.5 ps=100.33 w=100 l=2
X5 a_n18685_n61330# a_n18607_n61526# a_n18207_n61330# w_n18946_n61766# sky130_fd_pr__pfet_01v8 ad=3.3 pd=20.33 as=3.3 ps=20.33 w=20 l=2
X6 a_n18685_n61330# a_n18607_n61526# a_n18207_n61330# w_n18946_n61766# sky130_fd_pr__pfet_01v8 ad=3.3 pd=20.33 as=3.3 ps=20.33 w=20 l=2
X7 OP GP TS w_n8184_n54494# sky130_fd_pr__pfet_01v8 ad=16.5 pd=100.33 as=16.5 ps=100.33 w=100 l=2
X8 ON GN TS w_n8184_n54494# sky130_fd_pr__pfet_01v8 ad=16.5 pd=100.33 as=16.5 ps=100.33 w=100 l=2
X9 ON GN TS w_n8184_n54494# sky130_fd_pr__pfet_01v8 ad=16.5 pd=100.33 as=16.5 ps=100.33 w=100 l=2
X10 a_n18685_n61330# a_n18607_n61526# a_n18207_n61330# w_n18946_n61766# sky130_fd_pr__pfet_01v8 ad=3.3 pd=20.33 as=3.3 ps=20.33 w=20 l=2
X11 TS GP OP w_n8184_n54494# sky130_fd_pr__pfet_01v8 ad=16.5 pd=100.33 as=16.5 ps=100.33 w=100 l=2
X12 a_n18685_n61330# a_n18607_n61526# a_n18207_n61330# w_n18946_n61766# sky130_fd_pr__pfet_01v8 ad=3.3 pd=20.33 as=3.3 ps=20.33 w=20 l=2
X13 a_n18207_n61330# a_n18607_n61526# a_n18685_n61330# w_n18946_n61766# sky130_fd_pr__pfet_01v8 ad=3.3 pd=20.33 as=3.3 ps=20.33 w=20 l=2
X14 TS GN ON w_n8184_n54494# sky130_fd_pr__pfet_01v8 ad=16.5 pd=100.33 as=16.5 ps=100.33 w=100 l=2
X15 a_n18207_n61330# a_n18607_n61526# a_n18685_n61330# w_n18946_n61766# sky130_fd_pr__pfet_01v8 ad=3.3 pd=20.33 as=3.3 ps=20.33 w=20 l=2
X16 a_n18685_n61330# a_n18607_n61526# a_n18207_n61330# w_n18946_n61766# sky130_fd_pr__pfet_01v8 ad=3.3 pd=20.33 as=3.3 ps=20.33 w=20 l=2
X17 a_n18207_n61330# a_n18607_n61526# a_n18685_n61330# w_n18946_n61766# sky130_fd_pr__pfet_01v8 ad=3.3 pd=20.33 as=3.3 ps=20.33 w=20 l=2
X18 OP GP TS w_n8184_n54494# sky130_fd_pr__pfet_01v8 ad=16.5 pd=100.33 as=16.5 ps=100.33 w=100 l=2
X19 ON GN TS w_n8184_n54494# sky130_fd_pr__pfet_01v8 ad=16.5 pd=100.33 as=16.5 ps=100.33 w=100 l=2
X20 a_n18685_n61330# a_n18607_n61526# a_n18207_n61330# w_n18946_n61766# sky130_fd_pr__pfet_01v8 ad=3.3 pd=20.33 as=3.3 ps=20.33 w=20 l=2
X21 a_n18207_n61330# a_n18607_n61526# a_n18685_n61330# w_n18946_n61766# sky130_fd_pr__pfet_01v8 ad=3.3 pd=20.33 as=3.3 ps=20.33 w=20 l=2
X22 OP GP TS w_n8184_n54494# sky130_fd_pr__pfet_01v8 ad=16.5 pd=100.33 as=16.5 ps=100.33 w=100 l=2
X23 a_n18685_n61330# a_n18607_n61526# a_n18207_n61330# w_n18946_n61766# sky130_fd_pr__pfet_01v8 ad=3.3 pd=20.33 as=3.3 ps=20.33 w=20 l=2
X24 TS GN ON w_n8184_n54494# sky130_fd_pr__pfet_01v8 ad=16.5 pd=100.33 as=16.5 ps=100.33 w=100 l=2
X25 a_n18685_n61330# a_n18607_n61526# a_n18207_n61330# w_n18946_n61766# sky130_fd_pr__pfet_01v8 ad=3.3 pd=20.33 as=3.3 ps=20.33 w=20 l=2
X26 TS GN ON w_n8184_n54494# sky130_fd_pr__pfet_01v8 ad=16.5 pd=100.33 as=16.5 ps=100.33 w=100 l=2
X27 a_n18685_n61330# a_n18607_n61526# a_n18207_n61330# w_n18946_n61766# sky130_fd_pr__pfet_01v8 ad=3.3 pd=20.33 as=3.3 ps=20.33 w=20 l=2
X28 OP GP TS w_n8184_n54494# sky130_fd_pr__pfet_01v8 ad=16.5 pd=100.33 as=16.5 ps=100.33 w=100 l=2
X29 a_n18685_n61330# a_n18607_n61526# a_n18207_n61330# w_n18946_n61766# sky130_fd_pr__pfet_01v8 ad=3.3 pd=20.33 as=3.3 ps=20.33 w=20 l=2
X30 a_n18207_n61330# a_n18607_n61526# a_n18685_n61330# w_n18946_n61766# sky130_fd_pr__pfet_01v8 ad=3.3 pd=20.33 as=3.3 ps=20.33 w=20 l=2
X31 a_n18207_n61330# a_n18607_n61526# a_n18685_n61330# w_n18946_n61766# sky130_fd_pr__pfet_01v8 ad=3.3 pd=20.33 as=3.3 ps=20.33 w=20 l=2
X32 a_n18207_n61330# a_n18607_n61526# a_n18685_n61330# w_n18946_n61766# sky130_fd_pr__pfet_01v8 ad=3.3 pd=20.33 as=3.3 ps=20.33 w=20 l=2
X33 TS GP OP w_n8184_n54494# sky130_fd_pr__pfet_01v8 ad=16.5 pd=100.33 as=16.5 ps=100.33 w=100 l=2
X34 a_n18685_n61330# a_n18607_n61526# a_n18207_n61330# w_n18946_n61766# sky130_fd_pr__pfet_01v8 ad=3.3 pd=20.33 as=3.3 ps=20.33 w=20 l=2
X35 a_n18207_n61330# a_n18607_n61526# a_n18685_n61330# w_n18946_n61766# sky130_fd_pr__pfet_01v8 ad=3.3 pd=20.33 as=3.3 ps=20.33 w=20 l=2
X36 OP GP TS w_n8184_n54494# sky130_fd_pr__pfet_01v8 ad=16.5 pd=100.33 as=16.5 ps=100.33 w=100 l=2
X37 ON GN TS w_n8184_n54494# sky130_fd_pr__pfet_01v8 ad=16.5 pd=100.33 as=16.5 ps=100.33 w=100 l=2
X38 a_n18685_n61330# a_n18607_n61526# a_n18207_n61330# w_n18946_n61766# sky130_fd_pr__pfet_01v8 ad=3.3 pd=20.33 as=3.3 ps=20.33 w=20 l=2
X39 TS GP OP w_n8184_n54494# sky130_fd_pr__pfet_01v8 ad=16.5 pd=100.33 as=16.5 ps=100.33 w=100 l=2
X40 ON GN TS w_n8184_n54494# sky130_fd_pr__pfet_01v8 ad=16.5 pd=100.33 as=39 ps=200.78 w=100 l=2
X41 a_n18207_n61330# a_n18607_n61526# a_n18685_n61330# w_n18946_n61766# sky130_fd_pr__pfet_01v8 ad=3.3 pd=20.33 as=3.3 ps=20.33 w=20 l=2
X42 a_n18685_n61330# a_n18607_n61526# a_n18207_n61330# w_n18946_n61766# sky130_fd_pr__pfet_01v8 ad=3.3 pd=20.33 as=3.3 ps=20.33 w=20 l=2
X43 a_n18685_n61330# a_n18607_n61526# a_n18207_n61330# w_n18946_n61766# sky130_fd_pr__pfet_01v8 ad=3.3 pd=20.33 as=3.3 ps=20.33 w=20 l=2
X44 a_n18207_n61330# a_n18607_n61526# a_n18685_n61330# w_n18946_n61766# sky130_fd_pr__pfet_01v8 ad=3.3 pd=20.33 as=3.3 ps=20.33 w=20 l=2
X45 TS GP OP w_n8184_n54494# sky130_fd_pr__pfet_01v8 ad=16.5 pd=100.33 as=16.5 ps=100.33 w=100 l=2
X46 ON GN TS w_n8184_n54494# sky130_fd_pr__pfet_01v8 ad=16.5 pd=100.33 as=16.5 ps=100.33 w=100 l=2
X47 a_n18207_n61330# a_n18607_n61526# a_n18685_n61330# w_n18946_n61766# sky130_fd_pr__pfet_01v8 ad=3.3 pd=20.33 as=3.3 ps=20.33 w=20 l=2
X48 a_n18685_n61330# a_n18607_n61526# a_n18207_n61330# w_n18946_n61766# sky130_fd_pr__pfet_01v8 ad=3.3 pd=20.33 as=3.3 ps=20.33 w=20 l=2
X49 TS GP OP w_n8184_n54494# sky130_fd_pr__pfet_01v8 ad=16.5 pd=100.33 as=16.5 ps=100.33 w=100 l=2
X50 a_n18685_n61330# a_n18607_n61526# a_n18207_n61330# w_n18946_n61766# sky130_fd_pr__pfet_01v8 ad=3.3 pd=20.33 as=3.3 ps=20.33 w=20 l=2
X51 OP GP TS w_n8184_n54494# sky130_fd_pr__pfet_01v8 ad=16.5 pd=100.33 as=16.5 ps=100.33 w=100 l=2
X52 a_n18207_n61330# a_n18607_n61526# a_n18685_n61330# w_n18946_n61766# sky130_fd_pr__pfet_01v8 ad=3.3 pd=20.33 as=3.3 ps=20.33 w=20 l=2
X53 TS GN ON w_n8184_n54494# sky130_fd_pr__pfet_01v8 ad=16.5 pd=100.33 as=16.5 ps=100.33 w=100 l=2
X54 a_n18207_n61330# a_n18607_n61526# a_n18685_n61330# w_n18946_n61766# sky130_fd_pr__pfet_01v8 ad=3.3 pd=20.33 as=3.3 ps=20.33 w=20 l=2
X55 a_n18685_n61330# a_n18607_n61526# a_n18207_n61330# w_n18946_n61766# sky130_fd_pr__pfet_01v8 ad=3.3 pd=20.33 as=3.3 ps=20.33 w=20 l=2
X56 TS GP OP w_n8184_n54494# sky130_fd_pr__pfet_01v8 ad=16.5 pd=100.33 as=16.5 ps=100.33 w=100 l=2
X57 a_n18685_n61330# a_n18607_n61526# a_n18207_n61330# w_n18946_n61766# sky130_fd_pr__pfet_01v8 ad=3.3 pd=20.33 as=3.3 ps=20.33 w=20 l=2
X58 a_n18207_n61330# a_n18607_n61526# a_n18685_n61330# w_n18946_n61766# sky130_fd_pr__pfet_01v8 ad=3.3 pd=20.33 as=3.3 ps=20.33 w=20 l=2
X59 OP GP TS w_n8184_n54494# sky130_fd_pr__pfet_01v8 ad=16.5 pd=100.33 as=16.5 ps=100.33 w=100 l=2
X60 a_n18685_n61330# a_n18607_n61526# a_n18207_n61330# w_n18946_n61766# sky130_fd_pr__pfet_01v8 ad=3.3 pd=20.33 as=3.3 ps=20.33 w=20 l=2
X61 ON GN TS w_n8184_n54494# sky130_fd_pr__pfet_01v8 ad=16.5 pd=100.33 as=16.5 ps=100.33 w=100 l=2
X62 a_n3156_n9945# a_n5372_n10196# a_n5450_n10000# VSUBS sky130_fd_pr__nfet_01v8 ad=0.0289 pd=0.68 as=0.0289 ps=0.68 w=2.7311k l=8.08
X63 a_n18207_n61330# a_n18607_n61526# a_n18685_n61330# w_n18946_n61766# sky130_fd_pr__pfet_01v8 ad=3.3 pd=20.33 as=3.3 ps=20.33 w=20 l=2
X64 TS GP OP w_n8184_n54494# sky130_fd_pr__pfet_01v8 ad=16.5 pd=100.33 as=16.5 ps=100.33 w=100 l=2
X65 a_n18207_n61330# a_n18607_n61526# a_n18685_n61330# w_n18946_n61766# sky130_fd_pr__pfet_01v8 ad=3.3 pd=20.33 as=3.3 ps=20.33 w=20 l=2
X66 a_n18207_n61330# a_n18607_n61526# a_n18685_n61330# w_n18946_n61766# sky130_fd_pr__pfet_01v8 ad=3.3 pd=20.33 as=3.3 ps=20.33 w=20 l=2
X67 TS GP OP w_n8184_n54494# sky130_fd_pr__pfet_01v8 ad=16.5 pd=100.33 as=16.5 ps=100.33 w=100 l=2
X68 a_n18207_n61330# a_n18607_n61526# a_n18685_n61330# w_n18946_n61766# sky130_fd_pr__pfet_01v8 ad=3.3 pd=20.33 as=3.3 ps=20.33 w=20 l=2
X69 TS GN ON w_n8184_n54494# sky130_fd_pr__pfet_01v8 ad=16.5 pd=100.33 as=16.5 ps=100.33 w=100 l=2
X70 ON GN TS w_n8184_n54494# sky130_fd_pr__pfet_01v8 ad=16.5 pd=100.33 as=16.5 ps=100.33 w=100 l=2
X71 OP GP TS w_n8184_n54494# sky130_fd_pr__pfet_01v8 ad=16.5 pd=100.33 as=39 ps=200.78 w=100 l=2
X72 a_n18207_n61330# a_n18607_n61526# a_n18685_n61330# w_n18946_n61766# sky130_fd_pr__pfet_01v8 ad=3.3 pd=20.33 as=3.3 ps=20.33 w=20 l=2
X73 OP GP TS w_n8184_n54494# sky130_fd_pr__pfet_01v8 ad=16.5 pd=100.33 as=39 ps=200.78 w=100 l=2
X74 TS GN ON w_n8184_n54494# sky130_fd_pr__pfet_01v8 ad=16.5 pd=100.33 as=16.5 ps=100.33 w=100 l=2
X75 a_n18685_n61330# a_n18607_n61526# a_n18207_n61330# w_n18946_n61766# sky130_fd_pr__pfet_01v8 ad=3.3 pd=20.33 as=3.3 ps=20.33 w=20 l=2
X76 a_n18207_n61330# a_n18607_n61526# a_n18685_n61330# w_n18946_n61766# sky130_fd_pr__pfet_01v8 ad=3.3 pd=20.33 as=3.3 ps=20.33 w=20 l=2
X77 TS GN ON w_n8184_n54494# sky130_fd_pr__pfet_01v8 ad=16.5 pd=100.33 as=16.5 ps=100.33 w=100 l=2
X78 TS GN ON w_n8184_n54494# sky130_fd_pr__pfet_01v8 ad=16.5 pd=100.33 as=16.5 ps=100.33 w=100 l=2
X79 a_n18685_n61330# a_n18607_n61526# a_n18207_n61330# w_n18946_n61766# sky130_fd_pr__pfet_01v8 ad=7.8 pd=40.78 as=3.3 ps=20.33 w=20 l=2
X80 a_n18685_n61330# a_n18607_n61526# a_n18207_n61330# w_n18946_n61766# sky130_fd_pr__pfet_01v8 ad=3.3 pd=20.33 as=3.3 ps=20.33 w=20 l=2
X81 a_n18685_n61330# a_n18607_n61526# a_n18207_n61330# w_n18946_n61766# sky130_fd_pr__pfet_01v8 ad=3.3 pd=20.33 as=3.3 ps=20.33 w=20 l=2
X82 ON GN TS w_n8184_n54494# sky130_fd_pr__pfet_01v8 ad=16.5 pd=100.33 as=16.5 ps=100.33 w=100 l=2
X83 TS GN ON w_n8184_n54494# sky130_fd_pr__pfet_01v8 ad=16.5 pd=100.33 as=16.5 ps=100.33 w=100 l=2
X84 TS GP OP w_n8184_n54494# sky130_fd_pr__pfet_01v8 ad=16.5 pd=100.33 as=16.5 ps=100.33 w=100 l=2
X85 a_n18685_n61330# a_n18607_n61526# a_n18207_n61330# w_n18946_n61766# sky130_fd_pr__pfet_01v8 ad=3.3 pd=20.33 as=3.3 ps=20.33 w=20 l=2
X86 a_n18207_n61330# a_n18607_n61526# a_n18685_n61330# w_n18946_n61766# sky130_fd_pr__pfet_01v8 ad=3.3 pd=20.33 as=3.3 ps=20.33 w=20 l=2
X87 a_n18207_n61330# a_n18607_n61526# a_n18685_n61330# w_n18946_n61766# sky130_fd_pr__pfet_01v8 ad=3.3 pd=20.33 as=3.3 ps=20.33 w=20 l=2
X88 a_n18207_n61330# a_n18607_n61526# a_n18685_n61330# w_n18946_n61766# sky130_fd_pr__pfet_01v8 ad=3.3 pd=20.33 as=3.3 ps=20.33 w=20 l=2
X89 a_n18207_n61330# a_n18607_n61526# a_n18685_n61330# w_n18946_n61766# sky130_fd_pr__pfet_01v8 ad=3.3 pd=20.33 as=3.3 ps=20.33 w=20 l=2
X90 a_n18685_n61330# a_n18607_n61526# a_n18207_n61330# w_n18946_n61766# sky130_fd_pr__pfet_01v8 ad=3.3 pd=20.33 as=3.3 ps=20.33 w=20 l=2
X91 ON GN TS w_n8184_n54494# sky130_fd_pr__pfet_01v8 ad=16.5 pd=100.33 as=16.5 ps=100.33 w=100 l=2
X92 a_n18207_n61330# a_n18607_n61526# a_n18685_n61330# w_n18946_n61766# sky130_fd_pr__pfet_01v8 ad=3.3 pd=20.33 as=3.3 ps=20.33 w=20 l=2
X93 TS GP OP w_n8184_n54494# sky130_fd_pr__pfet_01v8 ad=16.5 pd=100.33 as=16.5 ps=100.33 w=100 l=2
X94 a_n18207_n61330# a_n18607_n61526# a_n18685_n61330# w_n18946_n61766# sky130_fd_pr__pfet_01v8 ad=3.3 pd=20.33 as=3.3 ps=20.33 w=20 l=2
X95 ON GN TS w_n8184_n54494# sky130_fd_pr__pfet_01v8 ad=16.5 pd=100.33 as=39 ps=200.78 w=100 l=2
X96 TS GN ON w_n8184_n54494# sky130_fd_pr__pfet_01v8 ad=16.5 pd=100.33 as=16.5 ps=100.33 w=100 l=2
X97 a_n18685_n61330# a_n18607_n61526# a_n18207_n61330# w_n18946_n61766# sky130_fd_pr__pfet_01v8 ad=3.3 pd=20.33 as=3.3 ps=20.33 w=20 l=2
X98 a_n18685_n61330# a_n18607_n61526# a_n18207_n61330# w_n18946_n61766# sky130_fd_pr__pfet_01v8 ad=3.3 pd=20.33 as=3.3 ps=20.33 w=20 l=2
X99 a_n18685_n61330# a_n18607_n61526# a_n18207_n61330# w_n18946_n61766# sky130_fd_pr__pfet_01v8 ad=3.3 pd=20.33 as=3.3 ps=20.33 w=20 l=2
X100 a_n18207_n61330# a_n18607_n61526# a_n18685_n61330# w_n18946_n61766# sky130_fd_pr__pfet_01v8 ad=3.3 pd=20.33 as=3.3 ps=20.33 w=20 l=2
X101 OP GP TS w_n8184_n54494# sky130_fd_pr__pfet_01v8 ad=16.5 pd=100.33 as=16.5 ps=100.33 w=100 l=2
X102 a_n18207_n61330# a_n18607_n61526# a_n18685_n61330# w_n18946_n61766# sky130_fd_pr__pfet_01v8 ad=3.3 pd=20.33 as=3.3 ps=20.33 w=20 l=2
X103 TS GP OP w_n8184_n54494# sky130_fd_pr__pfet_01v8 ad=16.5 pd=100.33 as=16.5 ps=100.33 w=100 l=2
X104 OP GP TS w_n8184_n54494# sky130_fd_pr__pfet_01v8 ad=16.5 pd=100.33 as=16.5 ps=100.33 w=100 l=2
X105 a_n18207_n61330# a_n18607_n61526# a_n18685_n61330# w_n18946_n61766# sky130_fd_pr__pfet_01v8 ad=3.3 pd=20.33 as=7.8 ps=40.78 w=20 l=2
X106 a_n18685_n61330# a_n18607_n61526# a_n18207_n61330# w_n18946_n61766# sky130_fd_pr__pfet_01v8 ad=3.3 pd=20.33 as=3.3 ps=20.33 w=20 l=2
X107 a_n18207_n61330# a_n18607_n61526# a_n18685_n61330# w_n18946_n61766# sky130_fd_pr__pfet_01v8 ad=3.3 pd=20.33 as=3.3 ps=20.33 w=20 l=2
X108 TS GP OP w_n8184_n54494# sky130_fd_pr__pfet_01v8 ad=39 pd=200.78 as=16.5 ps=100.33 w=100 l=2
X109 a_n18685_n61330# a_n18607_n61526# a_n18207_n61330# w_n18946_n61766# sky130_fd_pr__pfet_01v8 ad=3.3 pd=20.33 as=3.3 ps=20.33 w=20 l=2
X110 TS GN ON w_n8184_n54494# sky130_fd_pr__pfet_01v8 ad=39 pd=200.78 as=16.5 ps=100.33 w=100 l=2
X111 a_n18685_n61330# a_n18607_n61526# a_n18207_n61330# w_n18946_n61766# sky130_fd_pr__pfet_01v8 ad=3.3 pd=20.33 as=3.3 ps=20.33 w=20 l=2
X112 OP GP TS w_n8184_n54494# sky130_fd_pr__pfet_01v8 ad=16.5 pd=100.33 as=16.5 ps=100.33 w=100 l=2
X113 TS GP OP w_n8184_n54494# sky130_fd_pr__pfet_01v8 ad=16.5 pd=100.33 as=16.5 ps=100.33 w=100 l=2
X114 a_n18685_n61330# a_n18607_n61526# a_n18207_n61330# w_n18946_n61766# sky130_fd_pr__pfet_01v8 ad=3.3 pd=20.33 as=3.3 ps=20.33 w=20 l=2
X115 a_n18207_n61330# a_n18607_n61526# a_n18685_n61330# w_n18946_n61766# sky130_fd_pr__pfet_01v8 ad=3.3 pd=20.33 as=3.3 ps=20.33 w=20 l=2
X116 TS GN ON w_n8184_n54494# sky130_fd_pr__pfet_01v8 ad=16.5 pd=100.33 as=16.5 ps=100.33 w=100 l=2
X117 a_n18207_n61330# a_n18607_n61526# a_n18685_n61330# w_n18946_n61766# sky130_fd_pr__pfet_01v8 ad=3.3 pd=20.33 as=3.3 ps=20.33 w=20 l=2
X118 a_n18685_n61330# a_n18607_n61526# a_n18207_n61330# w_n18946_n61766# sky130_fd_pr__pfet_01v8 ad=3.3 pd=20.33 as=3.3 ps=20.33 w=20 l=2
X119 ON GN TS w_n8184_n54494# sky130_fd_pr__pfet_01v8 ad=16.5 pd=100.33 as=16.5 ps=100.33 w=100 l=2
X120 a_n18685_n61330# a_n18607_n61526# a_n18207_n61330# w_n18946_n61766# sky130_fd_pr__pfet_01v8 ad=3.3 pd=20.33 as=3.3 ps=20.33 w=20 l=2
X121 TS GP OP w_n8184_n54494# sky130_fd_pr__pfet_01v8 ad=16.5 pd=100.33 as=16.5 ps=100.33 w=100 l=2
X122 a_n18685_n61330# a_n18607_n61526# a_n18207_n61330# w_n18946_n61766# sky130_fd_pr__pfet_01v8 ad=3.3 pd=20.33 as=3.3 ps=20.33 w=20 l=2
X123 a_n18685_n61330# a_n18607_n61526# a_n18207_n61330# w_n18946_n61766# sky130_fd_pr__pfet_01v8 ad=3.3 pd=20.33 as=3.3 ps=20.33 w=20 l=2
X124 OP GP TS w_n8184_n54494# sky130_fd_pr__pfet_01v8 ad=16.5 pd=100.33 as=16.5 ps=100.33 w=100 l=2
X125 a_n18207_n61330# a_n18607_n61526# a_n18685_n61330# w_n18946_n61766# sky130_fd_pr__pfet_01v8 ad=3.3 pd=20.33 as=3.3 ps=20.33 w=20 l=2
X126 TS GN ON w_n8184_n54494# sky130_fd_pr__pfet_01v8 ad=16.5 pd=100.33 as=16.5 ps=100.33 w=100 l=2
X127 a_n18685_n61330# a_n18607_n61526# a_n18207_n61330# w_n18946_n61766# sky130_fd_pr__pfet_01v8 ad=3.3 pd=20.33 as=3.3 ps=20.33 w=20 l=2
X128 a_n18207_n61330# a_n18607_n61526# a_n18685_n61330# w_n18946_n61766# sky130_fd_pr__pfet_01v8 ad=3.3 pd=20.33 as=3.3 ps=20.33 w=20 l=2
X129 TS GP OP w_n8184_n54494# sky130_fd_pr__pfet_01v8 ad=16.5 pd=100.33 as=16.5 ps=100.33 w=100 l=2
X130 a_n18207_n61330# a_n18607_n61526# a_n18685_n61330# w_n18946_n61766# sky130_fd_pr__pfet_01v8 ad=3.3 pd=20.33 as=3.3 ps=20.33 w=20 l=2
X131 a_n18685_n61330# a_n18607_n61526# a_n18207_n61330# w_n18946_n61766# sky130_fd_pr__pfet_01v8 ad=3.3 pd=20.33 as=3.3 ps=20.33 w=20 l=2
X132 a_n18207_n61330# a_n18607_n61526# a_n18685_n61330# w_n18946_n61766# sky130_fd_pr__pfet_01v8 ad=3.3 pd=20.33 as=3.3 ps=20.33 w=20 l=2
X133 a_n18685_n61330# a_n18607_n61526# a_n18207_n61330# w_n18946_n61766# sky130_fd_pr__pfet_01v8 ad=3.3 pd=20.33 as=3.3 ps=20.33 w=20 l=2
X134 OP GP TS w_n8184_n54494# sky130_fd_pr__pfet_01v8 ad=16.5 pd=100.33 as=16.5 ps=100.33 w=100 l=2
X135 ON GN TS w_n8184_n54494# sky130_fd_pr__pfet_01v8 ad=16.5 pd=100.33 as=16.5 ps=100.33 w=100 l=2
X136 a_n18207_n61330# a_n18607_n61526# a_n18685_n61330# w_n18946_n61766# sky130_fd_pr__pfet_01v8 ad=3.3 pd=20.33 as=3.3 ps=20.33 w=20 l=2
X137 ON GN TS w_n8184_n54494# sky130_fd_pr__pfet_01v8 ad=16.5 pd=100.33 as=16.5 ps=100.33 w=100 l=2
X138 a_n18685_n61330# a_n18607_n61526# a_n18207_n61330# w_n18946_n61766# sky130_fd_pr__pfet_01v8 ad=3.3 pd=20.33 as=3.3 ps=20.33 w=20 l=2
X139 TS GN ON w_n8184_n54494# sky130_fd_pr__pfet_01v8 ad=39 pd=200.78 as=16.5 ps=100.33 w=100 l=2
X140 TS GP OP w_n8184_n54494# sky130_fd_pr__pfet_01v8 ad=39 pd=200.78 as=16.5 ps=100.33 w=100 l=2
X141 ON GN TS w_n8184_n54494# sky130_fd_pr__pfet_01v8 ad=16.5 pd=100.33 as=16.5 ps=100.33 w=100 l=2
X142 a_n18207_n61330# a_n18607_n61526# a_n18685_n61330# w_n18946_n61766# sky130_fd_pr__pfet_01v8 ad=3.3 pd=20.33 as=3.3 ps=20.33 w=20 l=2
X143 a_n18207_n61330# a_n18607_n61526# a_n18685_n61330# w_n18946_n61766# sky130_fd_pr__pfet_01v8 ad=3.3 pd=20.33 as=3.3 ps=20.33 w=20 l=2
X144 ON GN TS w_n8184_n54494# sky130_fd_pr__pfet_01v8 ad=16.5 pd=100.33 as=16.5 ps=100.33 w=100 l=2
C0 OP ON 5.13985f
C1 w_n8184_n54494# ON 8.16896f
C2 TS ON 0.12254p
C3 w_n8184_n54494# OP 7.65378f
C4 a_n18685_n61330# a_n18207_n61330# 74.3552f
C5 TS OP 0.12252p
C6 GN ON 0.2508p
C7 a_n5450_n10000# a_n3156_n9945# 8.7116f
C8 w_n8184_n54494# TS 37.3931f
C9 a_n18607_n61526# a_n18207_n61330# 0.12157p
C10 GP ON 3.37422f
C11 a_n5372_n10196# a_n3156_n9945# 67.17329f
C12 w_n8184_n54494# GN 23.4566f
C13 a_n18607_n61526# a_n18685_n61330# 0.1283p
C14 w_n18946_n61766# a_n18207_n61330# 19.4786f
C15 GN TS 0.24703p
C16 GP OP 0.2538p
C17 a_n5372_n10196# a_n5450_n10000# 67.5879f
C18 w_n8184_n54494# GP 23.7258f
C19 w_n18946_n61766# a_n18685_n61330# 6.34279f
C20 GP TS 0.24707p
C21 GP GN 29.2449f
C22 w_n18946_n61766# a_n18607_n61526# 66.42101f
C23 a_n18607_n61526# VSUBS 5.34853f **FLOATING
C24 ON VSUBS 12.696f **FLOATING
C25 OP VSUBS 14.392f **FLOATING
C26 TS VSUBS 10.458f **FLOATING
C27 GN VSUBS 8.37545f **FLOATING
C28 GP VSUBS 5.16135f **FLOATING
C29 a_n3156_n9945# VSUBS 9.55171f **FLOATING
C30 a_n5450_n10000# VSUBS 8.5265f **FLOATING
C31 a_n5372_n10196# VSUBS 8.99943f **FLOATING
C32 w_n18946_n61766# VSUBS 0.5773p **FLOATING
C33 w_n8184_n54494# VSUBS 2.0554p **FLOATING
