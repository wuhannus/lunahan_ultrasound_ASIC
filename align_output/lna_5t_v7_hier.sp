* SPICE3 file created from LNA_V7.ext - technology: sky130A

.subckt Unnamed_1eac1f09 a_n2544_n10000# a_n2466_n10196# a_n866_n10000# VSUBS
X0 a_n2544_n10000# a_n2466_n10196# a_n866_n10000# VSUBS sky130_fd_pr__nfet_01v8 ad=16.5 pd=100.33 as=16.5 ps=100.33 w=100 l=8
X1 a_n866_n10000# a_n2466_n10196# a_n2544_n10000# VSUBS sky130_fd_pr__nfet_01v8 ad=16.5 pd=100.33 as=39 ps=200.78 w=100 l=8
X2 a_n866_n10000# a_n2466_n10196# a_n2544_n10000# VSUBS sky130_fd_pr__nfet_01v8 ad=39 pd=200.78 as=16.5 ps=100.33 w=100 l=8
C0 a_n2466_n10196# a_n866_n10000# 27.6375f
C1 a_n2466_n10196# a_n2544_n10000# 28.6507f
C2 a_n2544_n10000# a_n866_n10000# 2.9801f
C3 a_n866_n10000# VSUBS 16.45165f
C4 a_n2544_n10000# VSUBS 15.49815f
.ends

.subckt Unnamed_9e7eb14f a_n2544_n10000# a_n2466_n10196# a_n866_n10000# VSUBS
X0 a_n2544_n10000# a_n2466_n10196# a_n866_n10000# VSUBS sky130_fd_pr__nfet_01v8 ad=16.5 pd=100.33 as=16.5 ps=100.33 w=100 l=8
X1 a_n866_n10000# a_n2466_n10196# a_n2544_n10000# VSUBS sky130_fd_pr__nfet_01v8 ad=16.5 pd=100.33 as=39 ps=200.78 w=100 l=8
X2 a_n866_n10000# a_n2466_n10196# a_n2544_n10000# VSUBS sky130_fd_pr__nfet_01v8 ad=39 pd=200.78 as=16.5 ps=100.33 w=100 l=8
C0 a_n2466_n10196# a_n866_n10000# 27.6375f
C1 a_n2466_n10196# a_n2544_n10000# 28.6507f
C2 a_n2544_n10000# a_n866_n10000# 2.9801f
C3 a_n866_n10000# VSUBS 16.45165f
C4 a_n2544_n10000# VSUBS 15.49815f
.ends

.subckt Unnamed_04f7c72c a_n18207_n2000# VSUBS
X0 a_n18685_n2000# a_n18607_n2196# a_n18207_n2000# w_n18946_n2436# sky130_fd_pr__pfet_01v8 ad=3.3 pd=20.33 as=3.3 ps=20.33 w=20 l=2
X1 a_n18685_n2000# a_n18607_n2196# a_n18207_n2000# w_n18946_n2436# sky130_fd_pr__pfet_01v8 ad=3.3 pd=20.33 as=3.3 ps=20.33 w=20 l=2
X2 a_n18207_n2000# a_n18607_n2196# a_n18685_n2000# w_n18946_n2436# sky130_fd_pr__pfet_01v8 ad=3.3 pd=20.33 as=3.3 ps=20.33 w=20 l=2
X3 a_n18685_n2000# a_n18607_n2196# a_n18207_n2000# w_n18946_n2436# sky130_fd_pr__pfet_01v8 ad=3.3 pd=20.33 as=3.3 ps=20.33 w=20 l=2
X4 a_n18207_n2000# a_n18607_n2196# a_n18685_n2000# w_n18946_n2436# sky130_fd_pr__pfet_01v8 ad=3.3 pd=20.33 as=3.3 ps=20.33 w=20 l=2
X5 a_n18207_n2000# a_n18607_n2196# a_n18685_n2000# w_n18946_n2436# sky130_fd_pr__pfet_01v8 ad=3.3 pd=20.33 as=3.3 ps=20.33 w=20 l=2
X6 a_n18685_n2000# a_n18607_n2196# a_n18207_n2000# w_n18946_n2436# sky130_fd_pr__pfet_01v8 ad=3.3 pd=20.33 as=3.3 ps=20.33 w=20 l=2
X7 a_n18685_n2000# a_n18607_n2196# a_n18207_n2000# w_n18946_n2436# sky130_fd_pr__pfet_01v8 ad=3.3 pd=20.33 as=3.3 ps=20.33 w=20 l=2
X8 a_n18685_n2000# a_n18607_n2196# a_n18207_n2000# w_n18946_n2436# sky130_fd_pr__pfet_01v8 ad=3.3 pd=20.33 as=3.3 ps=20.33 w=20 l=2
X9 a_n18207_n2000# a_n18607_n2196# a_n18685_n2000# w_n18946_n2436# sky130_fd_pr__pfet_01v8 ad=3.3 pd=20.33 as=3.3 ps=20.33 w=20 l=2
X10 a_n18207_n2000# a_n18607_n2196# a_n18685_n2000# w_n18946_n2436# sky130_fd_pr__pfet_01v8 ad=3.3 pd=20.33 as=3.3 ps=20.33 w=20 l=2
X11 a_n18207_n2000# a_n18607_n2196# a_n18685_n2000# w_n18946_n2436# sky130_fd_pr__pfet_01v8 ad=3.3 pd=20.33 as=3.3 ps=20.33 w=20 l=2
X12 a_n18207_n2000# a_n18607_n2196# a_n18685_n2000# w_n18946_n2436# sky130_fd_pr__pfet_01v8 ad=3.3 pd=20.33 as=3.3 ps=20.33 w=20 l=2
X13 a_n18207_n2000# a_n18607_n2196# a_n18685_n2000# w_n18946_n2436# sky130_fd_pr__pfet_01v8 ad=3.3 pd=20.33 as=3.3 ps=20.33 w=20 l=2
X14 a_n18685_n2000# a_n18607_n2196# a_n18207_n2000# w_n18946_n2436# sky130_fd_pr__pfet_01v8 ad=3.3 pd=20.33 as=3.3 ps=20.33 w=20 l=2
X15 a_n18685_n2000# a_n18607_n2196# a_n18207_n2000# w_n18946_n2436# sky130_fd_pr__pfet_01v8 ad=3.3 pd=20.33 as=3.3 ps=20.33 w=20 l=2
X16 a_n18685_n2000# a_n18607_n2196# a_n18207_n2000# w_n18946_n2436# sky130_fd_pr__pfet_01v8 ad=3.3 pd=20.33 as=3.3 ps=20.33 w=20 l=2
X17 a_n18207_n2000# a_n18607_n2196# a_n18685_n2000# w_n18946_n2436# sky130_fd_pr__pfet_01v8 ad=3.3 pd=20.33 as=3.3 ps=20.33 w=20 l=2
X18 a_n18685_n2000# a_n18607_n2196# a_n18207_n2000# w_n18946_n2436# sky130_fd_pr__pfet_01v8 ad=3.3 pd=20.33 as=3.3 ps=20.33 w=20 l=2
X19 a_n18685_n2000# a_n18607_n2196# a_n18207_n2000# w_n18946_n2436# sky130_fd_pr__pfet_01v8 ad=3.3 pd=20.33 as=3.3 ps=20.33 w=20 l=2
X20 a_n18685_n2000# a_n18607_n2196# a_n18207_n2000# w_n18946_n2436# sky130_fd_pr__pfet_01v8 ad=7.8 pd=40.78 as=3.3 ps=20.33 w=20 l=2
X21 a_n18685_n2000# a_n18607_n2196# a_n18207_n2000# w_n18946_n2436# sky130_fd_pr__pfet_01v8 ad=3.3 pd=20.33 as=3.3 ps=20.33 w=20 l=2
X22 a_n18207_n2000# a_n18607_n2196# a_n18685_n2000# w_n18946_n2436# sky130_fd_pr__pfet_01v8 ad=3.3 pd=20.33 as=3.3 ps=20.33 w=20 l=2
X23 a_n18207_n2000# a_n18607_n2196# a_n18685_n2000# w_n18946_n2436# sky130_fd_pr__pfet_01v8 ad=3.3 pd=20.33 as=3.3 ps=20.33 w=20 l=2
X24 a_n18207_n2000# a_n18607_n2196# a_n18685_n2000# w_n18946_n2436# sky130_fd_pr__pfet_01v8 ad=3.3 pd=20.33 as=3.3 ps=20.33 w=20 l=2
X25 a_n18685_n2000# a_n18607_n2196# a_n18207_n2000# w_n18946_n2436# sky130_fd_pr__pfet_01v8 ad=3.3 pd=20.33 as=3.3 ps=20.33 w=20 l=2
X26 a_n18685_n2000# a_n18607_n2196# a_n18207_n2000# w_n18946_n2436# sky130_fd_pr__pfet_01v8 ad=3.3 pd=20.33 as=3.3 ps=20.33 w=20 l=2
X27 a_n18685_n2000# a_n18607_n2196# a_n18207_n2000# w_n18946_n2436# sky130_fd_pr__pfet_01v8 ad=3.3 pd=20.33 as=3.3 ps=20.33 w=20 l=2
X28 a_n18207_n2000# a_n18607_n2196# a_n18685_n2000# w_n18946_n2436# sky130_fd_pr__pfet_01v8 ad=3.3 pd=20.33 as=3.3 ps=20.33 w=20 l=2
X29 a_n18685_n2000# a_n18607_n2196# a_n18207_n2000# w_n18946_n2436# sky130_fd_pr__pfet_01v8 ad=3.3 pd=20.33 as=3.3 ps=20.33 w=20 l=2
X30 a_n18685_n2000# a_n18607_n2196# a_n18207_n2000# w_n18946_n2436# sky130_fd_pr__pfet_01v8 ad=3.3 pd=20.33 as=3.3 ps=20.33 w=20 l=2
X31 a_n18207_n2000# a_n18607_n2196# a_n18685_n2000# w_n18946_n2436# sky130_fd_pr__pfet_01v8 ad=3.3 pd=20.33 as=3.3 ps=20.33 w=20 l=2
X32 a_n18207_n2000# a_n18607_n2196# a_n18685_n2000# w_n18946_n2436# sky130_fd_pr__pfet_01v8 ad=3.3 pd=20.33 as=3.3 ps=20.33 w=20 l=2
X33 a_n18207_n2000# a_n18607_n2196# a_n18685_n2000# w_n18946_n2436# sky130_fd_pr__pfet_01v8 ad=3.3 pd=20.33 as=3.3 ps=20.33 w=20 l=2
X34 a_n18207_n2000# a_n18607_n2196# a_n18685_n2000# w_n18946_n2436# sky130_fd_pr__pfet_01v8 ad=3.3 pd=20.33 as=3.3 ps=20.33 w=20 l=2
X35 a_n18685_n2000# a_n18607_n2196# a_n18207_n2000# w_n18946_n2436# sky130_fd_pr__pfet_01v8 ad=3.3 pd=20.33 as=3.3 ps=20.33 w=20 l=2
X36 a_n18207_n2000# a_n18607_n2196# a_n18685_n2000# w_n18946_n2436# sky130_fd_pr__pfet_01v8 ad=3.3 pd=20.33 as=3.3 ps=20.33 w=20 l=2
X37 a_n18685_n2000# a_n18607_n2196# a_n18207_n2000# w_n18946_n2436# sky130_fd_pr__pfet_01v8 ad=3.3 pd=20.33 as=3.3 ps=20.33 w=20 l=2
X38 a_n18207_n2000# a_n18607_n2196# a_n18685_n2000# w_n18946_n2436# sky130_fd_pr__pfet_01v8 ad=3.3 pd=20.33 as=3.3 ps=20.33 w=20 l=2
X39 a_n18207_n2000# a_n18607_n2196# a_n18685_n2000# w_n18946_n2436# sky130_fd_pr__pfet_01v8 ad=3.3 pd=20.33 as=3.3 ps=20.33 w=20 l=2
X40 a_n18685_n2000# a_n18607_n2196# a_n18207_n2000# w_n18946_n2436# sky130_fd_pr__pfet_01v8 ad=3.3 pd=20.33 as=3.3 ps=20.33 w=20 l=2
X41 a_n18207_n2000# a_n18607_n2196# a_n18685_n2000# w_n18946_n2436# sky130_fd_pr__pfet_01v8 ad=3.3 pd=20.33 as=3.3 ps=20.33 w=20 l=2
X42 a_n18685_n2000# a_n18607_n2196# a_n18207_n2000# w_n18946_n2436# sky130_fd_pr__pfet_01v8 ad=3.3 pd=20.33 as=3.3 ps=20.33 w=20 l=2
X43 a_n18207_n2000# a_n18607_n2196# a_n18685_n2000# w_n18946_n2436# sky130_fd_pr__pfet_01v8 ad=3.3 pd=20.33 as=7.8 ps=40.78 w=20 l=2
X44 a_n18207_n2000# a_n18607_n2196# a_n18685_n2000# w_n18946_n2436# sky130_fd_pr__pfet_01v8 ad=3.3 pd=20.33 as=3.3 ps=20.33 w=20 l=2
X45 a_n18207_n2000# a_n18607_n2196# a_n18685_n2000# w_n18946_n2436# sky130_fd_pr__pfet_01v8 ad=3.3 pd=20.33 as=3.3 ps=20.33 w=20 l=2
X46 a_n18685_n2000# a_n18607_n2196# a_n18207_n2000# w_n18946_n2436# sky130_fd_pr__pfet_01v8 ad=3.3 pd=20.33 as=3.3 ps=20.33 w=20 l=2
X47 a_n18685_n2000# a_n18607_n2196# a_n18207_n2000# w_n18946_n2436# sky130_fd_pr__pfet_01v8 ad=3.3 pd=20.33 as=3.3 ps=20.33 w=20 l=2
X48 a_n18207_n2000# a_n18607_n2196# a_n18685_n2000# w_n18946_n2436# sky130_fd_pr__pfet_01v8 ad=3.3 pd=20.33 as=3.3 ps=20.33 w=20 l=2
X49 a_n18685_n2000# a_n18607_n2196# a_n18207_n2000# w_n18946_n2436# sky130_fd_pr__pfet_01v8 ad=3.3 pd=20.33 as=3.3 ps=20.33 w=20 l=2
X50 a_n18207_n2000# a_n18607_n2196# a_n18685_n2000# w_n18946_n2436# sky130_fd_pr__pfet_01v8 ad=3.3 pd=20.33 as=3.3 ps=20.33 w=20 l=2
X51 a_n18685_n2000# a_n18607_n2196# a_n18207_n2000# w_n18946_n2436# sky130_fd_pr__pfet_01v8 ad=3.3 pd=20.33 as=3.3 ps=20.33 w=20 l=2
X52 a_n18685_n2000# a_n18607_n2196# a_n18207_n2000# w_n18946_n2436# sky130_fd_pr__pfet_01v8 ad=3.3 pd=20.33 as=3.3 ps=20.33 w=20 l=2
X53 a_n18685_n2000# a_n18607_n2196# a_n18207_n2000# w_n18946_n2436# sky130_fd_pr__pfet_01v8 ad=3.3 pd=20.33 as=3.3 ps=20.33 w=20 l=2
X54 a_n18685_n2000# a_n18607_n2196# a_n18207_n2000# w_n18946_n2436# sky130_fd_pr__pfet_01v8 ad=3.3 pd=20.33 as=3.3 ps=20.33 w=20 l=2
X55 a_n18207_n2000# a_n18607_n2196# a_n18685_n2000# w_n18946_n2436# sky130_fd_pr__pfet_01v8 ad=3.3 pd=20.33 as=3.3 ps=20.33 w=20 l=2
X56 a_n18207_n2000# a_n18607_n2196# a_n18685_n2000# w_n18946_n2436# sky130_fd_pr__pfet_01v8 ad=3.3 pd=20.33 as=3.3 ps=20.33 w=20 l=2
X57 a_n18207_n2000# a_n18607_n2196# a_n18685_n2000# w_n18946_n2436# sky130_fd_pr__pfet_01v8 ad=3.3 pd=20.33 as=3.3 ps=20.33 w=20 l=2
X58 a_n18207_n2000# a_n18607_n2196# a_n18685_n2000# w_n18946_n2436# sky130_fd_pr__pfet_01v8 ad=3.3 pd=20.33 as=3.3 ps=20.33 w=20 l=2
X59 a_n18685_n2000# a_n18607_n2196# a_n18207_n2000# w_n18946_n2436# sky130_fd_pr__pfet_01v8 ad=3.3 pd=20.33 as=3.3 ps=20.33 w=20 l=2
X60 a_n18207_n2000# a_n18607_n2196# a_n18685_n2000# w_n18946_n2436# sky130_fd_pr__pfet_01v8 ad=3.3 pd=20.33 as=3.3 ps=20.33 w=20 l=2
X61 a_n18685_n2000# a_n18607_n2196# a_n18207_n2000# w_n18946_n2436# sky130_fd_pr__pfet_01v8 ad=3.3 pd=20.33 as=3.3 ps=20.33 w=20 l=2
X62 a_n18207_n2000# a_n18607_n2196# a_n18685_n2000# w_n18946_n2436# sky130_fd_pr__pfet_01v8 ad=3.3 pd=20.33 as=3.3 ps=20.33 w=20 l=2
X63 a_n18685_n2000# a_n18607_n2196# a_n18207_n2000# w_n18946_n2436# sky130_fd_pr__pfet_01v8 ad=3.3 pd=20.33 as=3.3 ps=20.33 w=20 l=2
X64 a_n18685_n2000# a_n18607_n2196# a_n18207_n2000# w_n18946_n2436# sky130_fd_pr__pfet_01v8 ad=3.3 pd=20.33 as=3.3 ps=20.33 w=20 l=2
X65 a_n18685_n2000# a_n18607_n2196# a_n18207_n2000# w_n18946_n2436# sky130_fd_pr__pfet_01v8 ad=3.3 pd=20.33 as=3.3 ps=20.33 w=20 l=2
X66 a_n18207_n2000# a_n18607_n2196# a_n18685_n2000# w_n18946_n2436# sky130_fd_pr__pfet_01v8 ad=3.3 pd=20.33 as=3.3 ps=20.33 w=20 l=2
X67 a_n18685_n2000# a_n18607_n2196# a_n18207_n2000# w_n18946_n2436# sky130_fd_pr__pfet_01v8 ad=3.3 pd=20.33 as=3.3 ps=20.33 w=20 l=2
X68 a_n18685_n2000# a_n18607_n2196# a_n18207_n2000# w_n18946_n2436# sky130_fd_pr__pfet_01v8 ad=3.3 pd=20.33 as=3.3 ps=20.33 w=20 l=2
X69 a_n18685_n2000# a_n18607_n2196# a_n18207_n2000# w_n18946_n2436# sky130_fd_pr__pfet_01v8 ad=3.3 pd=20.33 as=3.3 ps=20.33 w=20 l=2
X70 a_n18207_n2000# a_n18607_n2196# a_n18685_n2000# w_n18946_n2436# sky130_fd_pr__pfet_01v8 ad=3.3 pd=20.33 as=3.3 ps=20.33 w=20 l=2
X71 a_n18207_n2000# a_n18607_n2196# a_n18685_n2000# w_n18946_n2436# sky130_fd_pr__pfet_01v8 ad=3.3 pd=20.33 as=3.3 ps=20.33 w=20 l=2
X72 a_n18685_n2000# a_n18607_n2196# a_n18207_n2000# w_n18946_n2436# sky130_fd_pr__pfet_01v8 ad=3.3 pd=20.33 as=3.3 ps=20.33 w=20 l=2
X73 a_n18685_n2000# a_n18607_n2196# a_n18207_n2000# w_n18946_n2436# sky130_fd_pr__pfet_01v8 ad=3.3 pd=20.33 as=3.3 ps=20.33 w=20 l=2
X74 a_n18207_n2000# a_n18607_n2196# a_n18685_n2000# w_n18946_n2436# sky130_fd_pr__pfet_01v8 ad=3.3 pd=20.33 as=3.3 ps=20.33 w=20 l=2
X75 a_n18207_n2000# a_n18607_n2196# a_n18685_n2000# w_n18946_n2436# sky130_fd_pr__pfet_01v8 ad=3.3 pd=20.33 as=3.3 ps=20.33 w=20 l=2
X76 a_n18685_n2000# a_n18607_n2196# a_n18207_n2000# w_n18946_n2436# sky130_fd_pr__pfet_01v8 ad=3.3 pd=20.33 as=3.3 ps=20.33 w=20 l=2
X77 a_n18207_n2000# a_n18607_n2196# a_n18685_n2000# w_n18946_n2436# sky130_fd_pr__pfet_01v8 ad=3.3 pd=20.33 as=3.3 ps=20.33 w=20 l=2
X78 a_n18207_n2000# a_n18607_n2196# a_n18685_n2000# w_n18946_n2436# sky130_fd_pr__pfet_01v8 ad=3.3 pd=20.33 as=3.3 ps=20.33 w=20 l=2
X79 a_n18207_n2000# a_n18607_n2196# a_n18685_n2000# w_n18946_n2436# sky130_fd_pr__pfet_01v8 ad=3.3 pd=20.33 as=3.3 ps=20.33 w=20 l=2
C0 w_n18946_n2436# a_n18685_n2000# 6.34415f
C1 w_n18946_n2436# a_n18607_n2196# 66.42101f
C2 a_n18685_n2000# a_n18207_n2000# 74.3282f
C3 a_n18607_n2196# a_n18207_n2000# 0.12157p
C4 w_n18946_n2436# a_n18207_n2000# 19.2736f
C5 a_n18607_n2196# a_n18685_n2000# 0.1283p
C6 a_n18207_n2000# VSUBS 2.67426f
C7 a_n18685_n2000# VSUBS 4.15943f
C8 w_n18946_n2436# VSUBS 0.5773p
.ends

.subckt diff_pair_5973376a a_n7532_n20447# a_n7132_n20397# a_n7532_201# a_n7610_n20397#
+ a_n7132_397# VSUBS
X0 a_n7610_n20397# a_n7532_201# a_n7132_397# w_n8184_n20996# sky130_fd_pr__pfet_01v8 ad=16.5 pd=100.33 as=16.5 ps=100.33 w=100 l=2
X1 a_n7132_n20397# a_n7532_n20447# a_n7610_n20397# w_n8184_n20996# sky130_fd_pr__pfet_01v8 ad=16.5 pd=100.33 as=16.5 ps=100.33 w=100 l=2
X2 a_n7610_n20397# a_n7532_201# a_n7132_397# w_n8184_n20996# sky130_fd_pr__pfet_01v8 ad=16.5 pd=100.33 as=16.5 ps=100.33 w=100 l=2
X3 a_n7132_397# a_n7532_201# a_n7610_n20397# w_n8184_n20996# sky130_fd_pr__pfet_01v8 ad=16.5 pd=100.33 as=16.5 ps=100.33 w=100 l=2
X4 a_n7132_397# a_n7532_201# a_n7610_n20397# w_n8184_n20996# sky130_fd_pr__pfet_01v8 ad=16.5 pd=100.33 as=16.5 ps=100.33 w=100 l=2
X5 a_n7610_n20397# a_n7532_n20447# a_n7132_n20397# w_n8184_n20996# sky130_fd_pr__pfet_01v8 ad=16.5 pd=100.33 as=16.5 ps=100.33 w=100 l=2
X6 a_n7132_n20397# a_n7532_n20447# a_n7610_n20397# w_n8184_n20996# sky130_fd_pr__pfet_01v8 ad=16.5 pd=100.33 as=39 ps=200.78 w=100 l=2
X7 a_n7610_n20397# a_n7532_201# a_n7132_397# w_n8184_n20996# sky130_fd_pr__pfet_01v8 ad=16.5 pd=100.33 as=16.5 ps=100.33 w=100 l=2
X8 a_n7610_n20397# a_n7532_201# a_n7132_397# w_n8184_n20996# sky130_fd_pr__pfet_01v8 ad=16.5 pd=100.33 as=16.5 ps=100.33 w=100 l=2
X9 a_n7610_n20397# a_n7532_201# a_n7132_397# w_n8184_n20996# sky130_fd_pr__pfet_01v8 ad=16.5 pd=100.33 as=16.5 ps=100.33 w=100 l=2
X10 a_n7132_397# a_n7532_201# a_n7610_n20397# w_n8184_n20996# sky130_fd_pr__pfet_01v8 ad=16.5 pd=100.33 as=16.5 ps=100.33 w=100 l=2
X11 a_n7610_n20397# a_n7532_201# a_n7132_397# w_n8184_n20996# sky130_fd_pr__pfet_01v8 ad=39 pd=200.78 as=16.5 ps=100.33 w=100 l=2
X12 a_n7610_n20397# a_n7532_n20447# a_n7132_n20397# w_n8184_n20996# sky130_fd_pr__pfet_01v8 ad=16.5 pd=100.33 as=16.5 ps=100.33 w=100 l=2
X13 a_n7132_n20397# a_n7532_n20447# a_n7610_n20397# w_n8184_n20996# sky130_fd_pr__pfet_01v8 ad=16.5 pd=100.33 as=16.5 ps=100.33 w=100 l=2
X14 a_n7132_397# a_n7532_201# a_n7610_n20397# w_n8184_n20996# sky130_fd_pr__pfet_01v8 ad=16.5 pd=100.33 as=39 ps=200.78 w=100 l=2
X15 a_n7610_n20397# a_n7532_n20447# a_n7132_n20397# w_n8184_n20996# sky130_fd_pr__pfet_01v8 ad=16.5 pd=100.33 as=16.5 ps=100.33 w=100 l=2
X16 a_n7610_n20397# a_n7532_201# a_n7132_397# w_n8184_n20996# sky130_fd_pr__pfet_01v8 ad=16.5 pd=100.33 as=16.5 ps=100.33 w=100 l=2
X17 a_n7132_n20397# a_n7532_n20447# a_n7610_n20397# w_n8184_n20996# sky130_fd_pr__pfet_01v8 ad=16.5 pd=100.33 as=16.5 ps=100.33 w=100 l=2
X18 a_n7610_n20397# a_n7532_n20447# a_n7132_n20397# w_n8184_n20996# sky130_fd_pr__pfet_01v8 ad=39 pd=200.78 as=16.5 ps=100.33 w=100 l=2
X19 a_n7132_n20397# a_n7532_n20447# a_n7610_n20397# w_n8184_n20996# sky130_fd_pr__pfet_01v8 ad=16.5 pd=100.33 as=16.5 ps=100.33 w=100 l=2
X20 a_n7610_n20397# a_n7532_n20447# a_n7132_n20397# w_n8184_n20996# sky130_fd_pr__pfet_01v8 ad=16.5 pd=100.33 as=16.5 ps=100.33 w=100 l=2
X21 a_n7132_397# a_n7532_201# a_n7610_n20397# w_n8184_n20996# sky130_fd_pr__pfet_01v8 ad=16.5 pd=100.33 as=16.5 ps=100.33 w=100 l=2
X22 a_n7132_n20397# a_n7532_n20447# a_n7610_n20397# w_n8184_n20996# sky130_fd_pr__pfet_01v8 ad=16.5 pd=100.33 as=16.5 ps=100.33 w=100 l=2
X23 a_n7610_n20397# a_n7532_201# a_n7132_397# w_n8184_n20996# sky130_fd_pr__pfet_01v8 ad=16.5 pd=100.33 as=16.5 ps=100.33 w=100 l=2
X24 a_n7132_n20397# a_n7532_n20447# a_n7610_n20397# w_n8184_n20996# sky130_fd_pr__pfet_01v8 ad=16.5 pd=100.33 as=39 ps=200.78 w=100 l=2
X25 a_n7132_n20397# a_n7532_n20447# a_n7610_n20397# w_n8184_n20996# sky130_fd_pr__pfet_01v8 ad=16.5 pd=100.33 as=16.5 ps=100.33 w=100 l=2
X26 a_n7610_n20397# a_n7532_n20447# a_n7132_n20397# w_n8184_n20996# sky130_fd_pr__pfet_01v8 ad=16.5 pd=100.33 as=16.5 ps=100.33 w=100 l=2
X27 a_n7132_n20397# a_n7532_n20447# a_n7610_n20397# w_n8184_n20996# sky130_fd_pr__pfet_01v8 ad=16.5 pd=100.33 as=16.5 ps=100.33 w=100 l=2
X28 a_n7610_n20397# a_n7532_201# a_n7132_397# w_n8184_n20996# sky130_fd_pr__pfet_01v8 ad=16.5 pd=100.33 as=16.5 ps=100.33 w=100 l=2
X29 a_n7132_397# a_n7532_201# a_n7610_n20397# w_n8184_n20996# sky130_fd_pr__pfet_01v8 ad=16.5 pd=100.33 as=16.5 ps=100.33 w=100 l=2
X30 a_n7610_n20397# a_n7532_201# a_n7132_397# w_n8184_n20996# sky130_fd_pr__pfet_01v8 ad=16.5 pd=100.33 as=16.5 ps=100.33 w=100 l=2
X31 a_n7132_397# a_n7532_201# a_n7610_n20397# w_n8184_n20996# sky130_fd_pr__pfet_01v8 ad=16.5 pd=100.33 as=16.5 ps=100.33 w=100 l=2
X32 a_n7610_n20397# a_n7532_n20447# a_n7132_n20397# w_n8184_n20996# sky130_fd_pr__pfet_01v8 ad=16.5 pd=100.33 as=16.5 ps=100.33 w=100 l=2
X33 a_n7610_n20397# a_n7532_201# a_n7132_397# w_n8184_n20996# sky130_fd_pr__pfet_01v8 ad=39 pd=200.78 as=16.5 ps=100.33 w=100 l=2
X34 a_n7132_397# a_n7532_201# a_n7610_n20397# w_n8184_n20996# sky130_fd_pr__pfet_01v8 ad=16.5 pd=100.33 as=16.5 ps=100.33 w=100 l=2
X35 a_n7610_n20397# a_n7532_n20447# a_n7132_n20397# w_n8184_n20996# sky130_fd_pr__pfet_01v8 ad=39 pd=200.78 as=16.5 ps=100.33 w=100 l=2
X36 a_n7132_n20397# a_n7532_n20447# a_n7610_n20397# w_n8184_n20996# sky130_fd_pr__pfet_01v8 ad=16.5 pd=100.33 as=16.5 ps=100.33 w=100 l=2
X37 a_n7610_n20397# a_n7532_n20447# a_n7132_n20397# w_n8184_n20996# sky130_fd_pr__pfet_01v8 ad=16.5 pd=100.33 as=16.5 ps=100.33 w=100 l=2
X38 a_n7610_n20397# a_n7532_201# a_n7132_397# w_n8184_n20996# sky130_fd_pr__pfet_01v8 ad=16.5 pd=100.33 as=16.5 ps=100.33 w=100 l=2
X39 a_n7610_n20397# a_n7532_201# a_n7132_397# w_n8184_n20996# sky130_fd_pr__pfet_01v8 ad=16.5 pd=100.33 as=16.5 ps=100.33 w=100 l=2
X40 a_n7132_397# a_n7532_201# a_n7610_n20397# w_n8184_n20996# sky130_fd_pr__pfet_01v8 ad=16.5 pd=100.33 as=16.5 ps=100.33 w=100 l=2
X41 a_n7610_n20397# a_n7532_n20447# a_n7132_n20397# w_n8184_n20996# sky130_fd_pr__pfet_01v8 ad=16.5 pd=100.33 as=16.5 ps=100.33 w=100 l=2
X42 a_n7132_397# a_n7532_201# a_n7610_n20397# w_n8184_n20996# sky130_fd_pr__pfet_01v8 ad=16.5 pd=100.33 as=16.5 ps=100.33 w=100 l=2
X43 a_n7132_397# a_n7532_201# a_n7610_n20397# w_n8184_n20996# sky130_fd_pr__pfet_01v8 ad=16.5 pd=100.33 as=16.5 ps=100.33 w=100 l=2
X44 a_n7132_n20397# a_n7532_n20447# a_n7610_n20397# w_n8184_n20996# sky130_fd_pr__pfet_01v8 ad=16.5 pd=100.33 as=16.5 ps=100.33 w=100 l=2
X45 a_n7132_n20397# a_n7532_n20447# a_n7610_n20397# w_n8184_n20996# sky130_fd_pr__pfet_01v8 ad=16.5 pd=100.33 as=16.5 ps=100.33 w=100 l=2
X46 a_n7610_n20397# a_n7532_n20447# a_n7132_n20397# w_n8184_n20996# sky130_fd_pr__pfet_01v8 ad=16.5 pd=100.33 as=16.5 ps=100.33 w=100 l=2
X47 a_n7132_n20397# a_n7532_n20447# a_n7610_n20397# w_n8184_n20996# sky130_fd_pr__pfet_01v8 ad=16.5 pd=100.33 as=16.5 ps=100.33 w=100 l=2
X48 a_n7132_n20397# a_n7532_n20447# a_n7610_n20397# w_n8184_n20996# sky130_fd_pr__pfet_01v8 ad=16.5 pd=100.33 as=16.5 ps=100.33 w=100 l=2
X49 a_n7610_n20397# a_n7532_n20447# a_n7132_n20397# w_n8184_n20996# sky130_fd_pr__pfet_01v8 ad=16.5 pd=100.33 as=16.5 ps=100.33 w=100 l=2
X50 a_n7132_397# a_n7532_201# a_n7610_n20397# w_n8184_n20996# sky130_fd_pr__pfet_01v8 ad=16.5 pd=100.33 as=16.5 ps=100.33 w=100 l=2
X51 a_n7132_397# a_n7532_201# a_n7610_n20397# w_n8184_n20996# sky130_fd_pr__pfet_01v8 ad=16.5 pd=100.33 as=39 ps=200.78 w=100 l=2
X52 a_n7610_n20397# a_n7532_201# a_n7132_397# w_n8184_n20996# sky130_fd_pr__pfet_01v8 ad=16.5 pd=100.33 as=16.5 ps=100.33 w=100 l=2
X53 a_n7132_397# a_n7532_201# a_n7610_n20397# w_n8184_n20996# sky130_fd_pr__pfet_01v8 ad=16.5 pd=100.33 as=16.5 ps=100.33 w=100 l=2
X54 a_n7610_n20397# a_n7532_n20447# a_n7132_n20397# w_n8184_n20996# sky130_fd_pr__pfet_01v8 ad=16.5 pd=100.33 as=16.5 ps=100.33 w=100 l=2
X55 a_n7132_n20397# a_n7532_n20447# a_n7610_n20397# w_n8184_n20996# sky130_fd_pr__pfet_01v8 ad=16.5 pd=100.33 as=16.5 ps=100.33 w=100 l=2
X56 a_n7610_n20397# a_n7532_201# a_n7132_397# w_n8184_n20996# sky130_fd_pr__pfet_01v8 ad=16.5 pd=100.33 as=16.5 ps=100.33 w=100 l=2
X57 a_n7610_n20397# a_n7532_201# a_n7132_397# w_n8184_n20996# sky130_fd_pr__pfet_01v8 ad=16.5 pd=100.33 as=16.5 ps=100.33 w=100 l=2
X58 a_n7132_n20397# a_n7532_n20447# a_n7610_n20397# w_n8184_n20996# sky130_fd_pr__pfet_01v8 ad=16.5 pd=100.33 as=16.5 ps=100.33 w=100 l=2
X59 a_n7132_397# a_n7532_201# a_n7610_n20397# w_n8184_n20996# sky130_fd_pr__pfet_01v8 ad=16.5 pd=100.33 as=16.5 ps=100.33 w=100 l=2
X60 a_n7132_397# a_n7532_201# a_n7610_n20397# w_n8184_n20996# sky130_fd_pr__pfet_01v8 ad=16.5 pd=100.33 as=16.5 ps=100.33 w=100 l=2
X61 a_n7610_n20397# a_n7532_n20447# a_n7132_n20397# w_n8184_n20996# sky130_fd_pr__pfet_01v8 ad=16.5 pd=100.33 as=16.5 ps=100.33 w=100 l=2
X62 a_n7610_n20397# a_n7532_n20447# a_n7132_n20397# w_n8184_n20996# sky130_fd_pr__pfet_01v8 ad=16.5 pd=100.33 as=16.5 ps=100.33 w=100 l=2
X63 a_n7610_n20397# a_n7532_n20447# a_n7132_n20397# w_n8184_n20996# sky130_fd_pr__pfet_01v8 ad=16.5 pd=100.33 as=16.5 ps=100.33 w=100 l=2
C0 w_n8184_n20996# a_n7532_n20447# 23.5667f
C1 a_n7132_397# a_n7132_n20397# 5.13884f
C2 w_n8184_n20996# a_n7532_201# 23.8234f
C3 a_n7610_n20397# a_n7132_n20397# 0.12096p
C4 a_n7610_n20397# a_n7132_397# 0.12093p
C5 a_n7532_n20447# a_n7132_n20397# 0.24846p
C6 a_n7532_201# a_n7132_n20397# 3.2788f
C7 w_n8184_n20996# a_n7132_n20397# 7.72733f
C8 a_n7532_n20447# a_n7610_n20397# 0.24703p
C9 a_n7532_201# a_n7132_397# 0.25153p
C10 w_n8184_n20996# a_n7132_397# 7.22806f
C11 a_n7532_201# a_n7610_n20397# 0.24708p
C12 w_n8184_n20996# a_n7610_n20397# 37.7315f
C13 a_n7532_201# a_n7532_n20447# 29.2471f
C14 a_n7132_n20397# VSUBS 7.10839f
C15 a_n7132_397# VSUBS 7.18635f
C16 a_n7610_n20397# VSUBS 17.23184f
C17 w_n8184_n20996# VSUBS 2.0554p
.ends

.subckt LNA_V7
XUnnamed_1eac1f09_0 m1_n5434_10036# m1_n4772_n10213# TS VSUBS Unnamed_1eac1f09
XUnnamed_9e7eb14f_0 m1_n5434_10036# m1_n4772_n10213# TS VSUBS Unnamed_9e7eb14f
XUnnamed_04f7c72c_0 TS VSUBS Unnamed_04f7c72c
Xdiff_pair_5973376a_0 GN TS GP TS TS VSUBS diff_pair_5973376a
C0 TS GP 14.17648f
C1 m1_n4772_n10213# m1_n5434_10036# 56.876f
C2 TS diff_pair_5973376a_0/w_n8184_n20996# 2.54357f
C3 m1_n5434_10036# TS 15.02818f
C4 m1_n4772_n10213# TS 63.98799f
C5 TS GN 13.81349f
C6 TS VSUBS 9.93874f
C7 m1_n4772_n10213# VSUBS -15.87674f
.ends
