* SPICE3 file created from LNA_V8_F.ext - technology: sky130A

X0 OP GP TS w_n8184_n54494# sky130_fd_pr__pfet_01v8 ad=16.5 pd=100.33 as=16.5 ps=100.33 w=100 l=2
X1 TS GN ON w_n8184_n54494# sky130_fd_pr__pfet_01v8 ad=16.5 pd=100.33 as=16.5 ps=100.33 w=100 l=2
X2 TS GN ON w_n8184_n54494# sky130_fd_pr__pfet_01v8 ad=16.5 pd=100.33 as=16.5 ps=100.33 w=100 l=2
X3 TS a_n18607_n61526# a_n18685_n61330# w_n18946_n61766# sky130_fd_pr__pfet_01v8 ad=3.3 pd=20.33 as=3.3 ps=20.33 w=20 l=2
X4 OP GP TS w_n8184_n54494# sky130_fd_pr__pfet_01v8 ad=16.5 pd=100.33 as=16.5 ps=100.33 w=100 l=2
X5 a_n18685_n61330# a_n18607_n61526# TS w_n18946_n61766# sky130_fd_pr__pfet_01v8 ad=3.3 pd=20.33 as=3.3 ps=20.33 w=20 l=2
X6 a_n18685_n61330# a_n18607_n61526# TS w_n18946_n61766# sky130_fd_pr__pfet_01v8 ad=3.3 pd=20.33 as=3.3 ps=20.33 w=20 l=2
X7 OP GP TS w_n8184_n54494# sky130_fd_pr__pfet_01v8 ad=16.5 pd=100.33 as=16.5 ps=100.33 w=100 l=2
X8 ON GN TS w_n8184_n54494# sky130_fd_pr__pfet_01v8 ad=16.5 pd=100.33 as=16.5 ps=100.33 w=100 l=2
X9 ON GN TS w_n8184_n54494# sky130_fd_pr__pfet_01v8 ad=16.5 pd=100.33 as=16.5 ps=100.33 w=100 l=2
X10 a_n18685_n61330# a_n18607_n61526# TS w_n18946_n61766# sky130_fd_pr__pfet_01v8 ad=3.3 pd=20.33 as=3.3 ps=20.33 w=20 l=2
X11 TS GP OP w_n8184_n54494# sky130_fd_pr__pfet_01v8 ad=16.5 pd=100.33 as=16.5 ps=100.33 w=100 l=2
X12 a_n18685_n61330# a_n18607_n61526# TS w_n18946_n61766# sky130_fd_pr__pfet_01v8 ad=3.3 pd=20.33 as=3.3 ps=20.33 w=20 l=2
X13 TS a_n18607_n61526# a_n18685_n61330# w_n18946_n61766# sky130_fd_pr__pfet_01v8 ad=3.3 pd=20.33 as=3.3 ps=20.33 w=20 l=2
X14 TS GN ON w_n8184_n54494# sky130_fd_pr__pfet_01v8 ad=16.5 pd=100.33 as=16.5 ps=100.33 w=100 l=2
X15 TS a_n18607_n61526# a_n18685_n61330# w_n18946_n61766# sky130_fd_pr__pfet_01v8 ad=3.3 pd=20.33 as=3.3 ps=20.33 w=20 l=2
X16 a_n18685_n61330# a_n18607_n61526# TS w_n18946_n61766# sky130_fd_pr__pfet_01v8 ad=3.3 pd=20.33 as=3.3 ps=20.33 w=20 l=2
X17 TS a_n18607_n61526# a_n18685_n61330# w_n18946_n61766# sky130_fd_pr__pfet_01v8 ad=3.3 pd=20.33 as=3.3 ps=20.33 w=20 l=2
X18 OP GP TS w_n8184_n54494# sky130_fd_pr__pfet_01v8 ad=16.5 pd=100.33 as=16.5 ps=100.33 w=100 l=2
X19 ON GN TS w_n8184_n54494# sky130_fd_pr__pfet_01v8 ad=16.5 pd=100.33 as=16.5 ps=100.33 w=100 l=2
X20 a_n18685_n61330# a_n18607_n61526# TS w_n18946_n61766# sky130_fd_pr__pfet_01v8 ad=3.3 pd=20.33 as=3.3 ps=20.33 w=20 l=2
X21 TS a_n18607_n61526# a_n18685_n61330# w_n18946_n61766# sky130_fd_pr__pfet_01v8 ad=3.3 pd=20.33 as=3.3 ps=20.33 w=20 l=2
X22 OP GP TS w_n8184_n54494# sky130_fd_pr__pfet_01v8 ad=16.5 pd=100.33 as=16.5 ps=100.33 w=100 l=2
X23 a_n18685_n61330# a_n18607_n61526# TS w_n18946_n61766# sky130_fd_pr__pfet_01v8 ad=3.3 pd=20.33 as=3.3 ps=20.33 w=20 l=2
X24 TS GN ON w_n8184_n54494# sky130_fd_pr__pfet_01v8 ad=16.5 pd=100.33 as=16.5 ps=100.33 w=100 l=2
X25 a_n18685_n61330# a_n18607_n61526# TS w_n18946_n61766# sky130_fd_pr__pfet_01v8 ad=3.3 pd=20.33 as=3.3 ps=20.33 w=20 l=2
X26 TS GN ON w_n8184_n54494# sky130_fd_pr__pfet_01v8 ad=16.5 pd=100.33 as=16.5 ps=100.33 w=100 l=2
X27 a_n18685_n61330# a_n18607_n61526# TS w_n18946_n61766# sky130_fd_pr__pfet_01v8 ad=3.3 pd=20.33 as=3.3 ps=20.33 w=20 l=2
X28 OP GP TS w_n8184_n54494# sky130_fd_pr__pfet_01v8 ad=16.5 pd=100.33 as=16.5 ps=100.33 w=100 l=2
X29 a_n18685_n61330# a_n18607_n61526# TS w_n18946_n61766# sky130_fd_pr__pfet_01v8 ad=3.3 pd=20.33 as=3.3 ps=20.33 w=20 l=2
X30 TS a_n18607_n61526# a_n18685_n61330# w_n18946_n61766# sky130_fd_pr__pfet_01v8 ad=3.3 pd=20.33 as=3.3 ps=20.33 w=20 l=2
X31 TS a_n18607_n61526# a_n18685_n61330# w_n18946_n61766# sky130_fd_pr__pfet_01v8 ad=3.3 pd=20.33 as=3.3 ps=20.33 w=20 l=2
X32 TS a_n18607_n61526# a_n18685_n61330# w_n18946_n61766# sky130_fd_pr__pfet_01v8 ad=3.3 pd=20.33 as=3.3 ps=20.33 w=20 l=2
X33 TS GP OP w_n8184_n54494# sky130_fd_pr__pfet_01v8 ad=16.5 pd=100.33 as=16.5 ps=100.33 w=100 l=2
X34 a_n18685_n61330# a_n18607_n61526# TS w_n18946_n61766# sky130_fd_pr__pfet_01v8 ad=3.3 pd=20.33 as=3.3 ps=20.33 w=20 l=2
X35 TS a_n18607_n61526# a_n18685_n61330# w_n18946_n61766# sky130_fd_pr__pfet_01v8 ad=3.3 pd=20.33 as=3.3 ps=20.33 w=20 l=2
X36 OP GP TS w_n8184_n54494# sky130_fd_pr__pfet_01v8 ad=16.5 pd=100.33 as=16.5 ps=100.33 w=100 l=2
X37 ON GN TS w_n8184_n54494# sky130_fd_pr__pfet_01v8 ad=16.5 pd=100.33 as=16.5 ps=100.33 w=100 l=2
X38 a_n18685_n61330# a_n18607_n61526# TS w_n18946_n61766# sky130_fd_pr__pfet_01v8 ad=3.3 pd=20.33 as=3.3 ps=20.33 w=20 l=2
X39 TS GP OP w_n8184_n54494# sky130_fd_pr__pfet_01v8 ad=16.5 pd=100.33 as=16.5 ps=100.33 w=100 l=2
X40 ON GN TS w_n8184_n54494# sky130_fd_pr__pfet_01v8 ad=16.5 pd=100.33 as=39 ps=200.78 w=100 l=2
X41 TS a_n18607_n61526# a_n18685_n61330# w_n18946_n61766# sky130_fd_pr__pfet_01v8 ad=3.3 pd=20.33 as=3.3 ps=20.33 w=20 l=2
X42 a_n18685_n61330# a_n18607_n61526# TS w_n18946_n61766# sky130_fd_pr__pfet_01v8 ad=3.3 pd=20.33 as=3.3 ps=20.33 w=20 l=2
X43 a_n18685_n61330# a_n18607_n61526# TS w_n18946_n61766# sky130_fd_pr__pfet_01v8 ad=3.3 pd=20.33 as=3.3 ps=20.33 w=20 l=2
X44 TS a_n18607_n61526# a_n18685_n61330# w_n18946_n61766# sky130_fd_pr__pfet_01v8 ad=3.3 pd=20.33 as=3.3 ps=20.33 w=20 l=2
X45 TS GP OP w_n8184_n54494# sky130_fd_pr__pfet_01v8 ad=16.5 pd=100.33 as=16.5 ps=100.33 w=100 l=2
X46 ON GN TS w_n8184_n54494# sky130_fd_pr__pfet_01v8 ad=16.5 pd=100.33 as=16.5 ps=100.33 w=100 l=2
X47 TS a_n18607_n61526# a_n18685_n61330# w_n18946_n61766# sky130_fd_pr__pfet_01v8 ad=3.3 pd=20.33 as=3.3 ps=20.33 w=20 l=2
X48 a_n18685_n61330# a_n18607_n61526# TS w_n18946_n61766# sky130_fd_pr__pfet_01v8 ad=3.3 pd=20.33 as=3.3 ps=20.33 w=20 l=2
X49 TS GP OP w_n8184_n54494# sky130_fd_pr__pfet_01v8 ad=16.5 pd=100.33 as=16.5 ps=100.33 w=100 l=2
X50 a_n18685_n61330# a_n18607_n61526# TS w_n18946_n61766# sky130_fd_pr__pfet_01v8 ad=3.3 pd=20.33 as=3.3 ps=20.33 w=20 l=2
X51 OP a_n5372_n10196# a_n5450_n10000# VSUBS sky130_fd_pr__nfet_01v8 ad=39 pd=200.78 as=16.5 ps=100.33 w=100 l=8
X52 OP GP TS w_n8184_n54494# sky130_fd_pr__pfet_01v8 ad=16.5 pd=100.33 as=16.5 ps=100.33 w=100 l=2
X53 TS a_n18607_n61526# a_n18685_n61330# w_n18946_n61766# sky130_fd_pr__pfet_01v8 ad=3.3 pd=20.33 as=3.3 ps=20.33 w=20 l=2
X54 TS GN ON w_n8184_n54494# sky130_fd_pr__pfet_01v8 ad=16.5 pd=100.33 as=16.5 ps=100.33 w=100 l=2
X55 TS a_n18607_n61526# a_n18685_n61330# w_n18946_n61766# sky130_fd_pr__pfet_01v8 ad=3.3 pd=20.33 as=3.3 ps=20.33 w=20 l=2
X56 a_n18685_n61330# a_n18607_n61526# TS w_n18946_n61766# sky130_fd_pr__pfet_01v8 ad=3.3 pd=20.33 as=3.3 ps=20.33 w=20 l=2
X57 TS GP OP w_n8184_n54494# sky130_fd_pr__pfet_01v8 ad=16.5 pd=100.33 as=16.5 ps=100.33 w=100 l=2
X58 a_n18685_n61330# a_n18607_n61526# TS w_n18946_n61766# sky130_fd_pr__pfet_01v8 ad=3.3 pd=20.33 as=3.3 ps=20.33 w=20 l=2
X59 ON a_n5372_n10196# a_n5450_n10000# VSUBS sky130_fd_pr__nfet_01v8 ad=16.5 pd=100.33 as=39 ps=200.78 w=100 l=8
X60 TS a_n18607_n61526# a_n18685_n61330# w_n18946_n61766# sky130_fd_pr__pfet_01v8 ad=3.3 pd=20.33 as=3.3 ps=20.33 w=20 l=2
X61 OP GP TS w_n8184_n54494# sky130_fd_pr__pfet_01v8 ad=16.5 pd=100.33 as=16.5 ps=100.33 w=100 l=2
X62 a_n18685_n61330# a_n18607_n61526# TS w_n18946_n61766# sky130_fd_pr__pfet_01v8 ad=3.3 pd=20.33 as=3.3 ps=20.33 w=20 l=2
X63 ON GN TS w_n8184_n54494# sky130_fd_pr__pfet_01v8 ad=16.5 pd=100.33 as=16.5 ps=100.33 w=100 l=2
X64 OP a_n5372_n10196# a_n5450_n10000# VSUBS sky130_fd_pr__nfet_01v8 ad=16.5 pd=100.33 as=39 ps=200.78 w=100 l=8
X65 TS a_n18607_n61526# a_n18685_n61330# w_n18946_n61766# sky130_fd_pr__pfet_01v8 ad=3.3 pd=20.33 as=3.3 ps=20.33 w=20 l=2
X66 TS GP OP w_n8184_n54494# sky130_fd_pr__pfet_01v8 ad=16.5 pd=100.33 as=16.5 ps=100.33 w=100 l=2
X67 TS a_n18607_n61526# a_n18685_n61330# w_n18946_n61766# sky130_fd_pr__pfet_01v8 ad=3.3 pd=20.33 as=3.3 ps=20.33 w=20 l=2
X68 TS a_n18607_n61526# a_n18685_n61330# w_n18946_n61766# sky130_fd_pr__pfet_01v8 ad=3.3 pd=20.33 as=3.3 ps=20.33 w=20 l=2
X69 TS GP OP w_n8184_n54494# sky130_fd_pr__pfet_01v8 ad=16.5 pd=100.33 as=16.5 ps=100.33 w=100 l=2
X70 TS a_n18607_n61526# a_n18685_n61330# w_n18946_n61766# sky130_fd_pr__pfet_01v8 ad=3.3 pd=20.33 as=3.3 ps=20.33 w=20 l=2
X71 TS GN ON w_n8184_n54494# sky130_fd_pr__pfet_01v8 ad=16.5 pd=100.33 as=16.5 ps=100.33 w=100 l=2
X72 ON GN TS w_n8184_n54494# sky130_fd_pr__pfet_01v8 ad=16.5 pd=100.33 as=16.5 ps=100.33 w=100 l=2
X73 OP GP TS w_n8184_n54494# sky130_fd_pr__pfet_01v8 ad=16.5 pd=100.33 as=39 ps=200.78 w=100 l=2
X74 TS a_n18607_n61526# a_n18685_n61330# w_n18946_n61766# sky130_fd_pr__pfet_01v8 ad=3.3 pd=20.33 as=3.3 ps=20.33 w=20 l=2
X75 OP GP TS w_n8184_n54494# sky130_fd_pr__pfet_01v8 ad=16.5 pd=100.33 as=39 ps=200.78 w=100 l=2
X76 TS GN ON w_n8184_n54494# sky130_fd_pr__pfet_01v8 ad=16.5 pd=100.33 as=16.5 ps=100.33 w=100 l=2
X77 a_n18685_n61330# a_n18607_n61526# TS w_n18946_n61766# sky130_fd_pr__pfet_01v8 ad=3.3 pd=20.33 as=3.3 ps=20.33 w=20 l=2
X78 TS a_n18607_n61526# a_n18685_n61330# w_n18946_n61766# sky130_fd_pr__pfet_01v8 ad=3.3 pd=20.33 as=3.3 ps=20.33 w=20 l=2
X79 TS GN ON w_n8184_n54494# sky130_fd_pr__pfet_01v8 ad=16.5 pd=100.33 as=16.5 ps=100.33 w=100 l=2
X80 TS GN ON w_n8184_n54494# sky130_fd_pr__pfet_01v8 ad=16.5 pd=100.33 as=16.5 ps=100.33 w=100 l=2
X81 a_n18685_n61330# a_n18607_n61526# TS w_n18946_n61766# sky130_fd_pr__pfet_01v8 ad=7.8 pd=40.78 as=3.3 ps=20.33 w=20 l=2
X82 a_n18685_n61330# a_n18607_n61526# TS w_n18946_n61766# sky130_fd_pr__pfet_01v8 ad=3.3 pd=20.33 as=3.3 ps=20.33 w=20 l=2
X83 a_n18685_n61330# a_n18607_n61526# TS w_n18946_n61766# sky130_fd_pr__pfet_01v8 ad=3.3 pd=20.33 as=3.3 ps=20.33 w=20 l=2
X84 ON GN TS w_n8184_n54494# sky130_fd_pr__pfet_01v8 ad=16.5 pd=100.33 as=16.5 ps=100.33 w=100 l=2
X85 TS GN ON w_n8184_n54494# sky130_fd_pr__pfet_01v8 ad=16.5 pd=100.33 as=16.5 ps=100.33 w=100 l=2
X86 a_n5450_n10000# a_n5372_n10196# OP VSUBS sky130_fd_pr__nfet_01v8 ad=16.5 pd=100.33 as=16.5 ps=100.33 w=100 l=8
X87 TS GP OP w_n8184_n54494# sky130_fd_pr__pfet_01v8 ad=16.5 pd=100.33 as=16.5 ps=100.33 w=100 l=2
X88 a_n18685_n61330# a_n18607_n61526# TS w_n18946_n61766# sky130_fd_pr__pfet_01v8 ad=3.3 pd=20.33 as=3.3 ps=20.33 w=20 l=2
X89 TS a_n18607_n61526# a_n18685_n61330# w_n18946_n61766# sky130_fd_pr__pfet_01v8 ad=3.3 pd=20.33 as=3.3 ps=20.33 w=20 l=2
X90 TS a_n18607_n61526# a_n18685_n61330# w_n18946_n61766# sky130_fd_pr__pfet_01v8 ad=3.3 pd=20.33 as=3.3 ps=20.33 w=20 l=2
X91 TS a_n18607_n61526# a_n18685_n61330# w_n18946_n61766# sky130_fd_pr__pfet_01v8 ad=3.3 pd=20.33 as=3.3 ps=20.33 w=20 l=2
X92 ON a_n5372_n10196# a_n5450_n10000# VSUBS sky130_fd_pr__nfet_01v8 ad=39 pd=200.78 as=16.5 ps=100.33 w=100 l=8
X93 TS a_n18607_n61526# a_n18685_n61330# w_n18946_n61766# sky130_fd_pr__pfet_01v8 ad=3.3 pd=20.33 as=3.3 ps=20.33 w=20 l=2
X94 a_n18685_n61330# a_n18607_n61526# TS w_n18946_n61766# sky130_fd_pr__pfet_01v8 ad=3.3 pd=20.33 as=3.3 ps=20.33 w=20 l=2
X95 ON GN TS w_n8184_n54494# sky130_fd_pr__pfet_01v8 ad=16.5 pd=100.33 as=16.5 ps=100.33 w=100 l=2
X96 TS a_n18607_n61526# a_n18685_n61330# w_n18946_n61766# sky130_fd_pr__pfet_01v8 ad=3.3 pd=20.33 as=3.3 ps=20.33 w=20 l=2
X97 TS GP OP w_n8184_n54494# sky130_fd_pr__pfet_01v8 ad=16.5 pd=100.33 as=16.5 ps=100.33 w=100 l=2
X98 TS a_n18607_n61526# a_n18685_n61330# w_n18946_n61766# sky130_fd_pr__pfet_01v8 ad=3.3 pd=20.33 as=3.3 ps=20.33 w=20 l=2
X99 ON GN TS w_n8184_n54494# sky130_fd_pr__pfet_01v8 ad=16.5 pd=100.33 as=39 ps=200.78 w=100 l=2
X100 TS GN ON w_n8184_n54494# sky130_fd_pr__pfet_01v8 ad=16.5 pd=100.33 as=16.5 ps=100.33 w=100 l=2
X101 a_n18685_n61330# a_n18607_n61526# TS w_n18946_n61766# sky130_fd_pr__pfet_01v8 ad=3.3 pd=20.33 as=3.3 ps=20.33 w=20 l=2
X102 a_n18685_n61330# a_n18607_n61526# TS w_n18946_n61766# sky130_fd_pr__pfet_01v8 ad=3.3 pd=20.33 as=3.3 ps=20.33 w=20 l=2
X103 a_n18685_n61330# a_n18607_n61526# TS w_n18946_n61766# sky130_fd_pr__pfet_01v8 ad=3.3 pd=20.33 as=3.3 ps=20.33 w=20 l=2
X104 TS a_n18607_n61526# a_n18685_n61330# w_n18946_n61766# sky130_fd_pr__pfet_01v8 ad=3.3 pd=20.33 as=3.3 ps=20.33 w=20 l=2
X105 OP GP TS w_n8184_n54494# sky130_fd_pr__pfet_01v8 ad=16.5 pd=100.33 as=16.5 ps=100.33 w=100 l=2
X106 a_n5450_n10000# a_n5372_n10196# ON VSUBS sky130_fd_pr__nfet_01v8 ad=16.5 pd=100.33 as=16.5 ps=100.33 w=100 l=8
X107 TS a_n18607_n61526# a_n18685_n61330# w_n18946_n61766# sky130_fd_pr__pfet_01v8 ad=3.3 pd=20.33 as=3.3 ps=20.33 w=20 l=2
X108 TS GP OP w_n8184_n54494# sky130_fd_pr__pfet_01v8 ad=16.5 pd=100.33 as=16.5 ps=100.33 w=100 l=2
X109 OP GP TS w_n8184_n54494# sky130_fd_pr__pfet_01v8 ad=16.5 pd=100.33 as=16.5 ps=100.33 w=100 l=2
X110 TS a_n18607_n61526# a_n18685_n61330# w_n18946_n61766# sky130_fd_pr__pfet_01v8 ad=3.3 pd=20.33 as=7.8 ps=40.78 w=20 l=2
X111 a_n18685_n61330# a_n18607_n61526# TS w_n18946_n61766# sky130_fd_pr__pfet_01v8 ad=3.3 pd=20.33 as=3.3 ps=20.33 w=20 l=2
X112 TS a_n18607_n61526# a_n18685_n61330# w_n18946_n61766# sky130_fd_pr__pfet_01v8 ad=3.3 pd=20.33 as=3.3 ps=20.33 w=20 l=2
X113 TS GP OP w_n8184_n54494# sky130_fd_pr__pfet_01v8 ad=39 pd=200.78 as=16.5 ps=100.33 w=100 l=2
X114 a_n18685_n61330# a_n18607_n61526# TS w_n18946_n61766# sky130_fd_pr__pfet_01v8 ad=3.3 pd=20.33 as=3.3 ps=20.33 w=20 l=2
X115 TS GN ON w_n8184_n54494# sky130_fd_pr__pfet_01v8 ad=39 pd=200.78 as=16.5 ps=100.33 w=100 l=2
X116 a_n18685_n61330# a_n18607_n61526# TS w_n18946_n61766# sky130_fd_pr__pfet_01v8 ad=3.3 pd=20.33 as=3.3 ps=20.33 w=20 l=2
X117 OP GP TS w_n8184_n54494# sky130_fd_pr__pfet_01v8 ad=16.5 pd=100.33 as=16.5 ps=100.33 w=100 l=2
X118 TS GP OP w_n8184_n54494# sky130_fd_pr__pfet_01v8 ad=16.5 pd=100.33 as=16.5 ps=100.33 w=100 l=2
X119 a_n18685_n61330# a_n18607_n61526# TS w_n18946_n61766# sky130_fd_pr__pfet_01v8 ad=3.3 pd=20.33 as=3.3 ps=20.33 w=20 l=2
X120 TS a_n18607_n61526# a_n18685_n61330# w_n18946_n61766# sky130_fd_pr__pfet_01v8 ad=3.3 pd=20.33 as=3.3 ps=20.33 w=20 l=2
X121 TS GN ON w_n8184_n54494# sky130_fd_pr__pfet_01v8 ad=16.5 pd=100.33 as=16.5 ps=100.33 w=100 l=2
X122 TS a_n18607_n61526# a_n18685_n61330# w_n18946_n61766# sky130_fd_pr__pfet_01v8 ad=3.3 pd=20.33 as=3.3 ps=20.33 w=20 l=2
X123 a_n18685_n61330# a_n18607_n61526# TS w_n18946_n61766# sky130_fd_pr__pfet_01v8 ad=3.3 pd=20.33 as=3.3 ps=20.33 w=20 l=2
X124 ON GN TS w_n8184_n54494# sky130_fd_pr__pfet_01v8 ad=16.5 pd=100.33 as=16.5 ps=100.33 w=100 l=2
X125 a_n18685_n61330# a_n18607_n61526# TS w_n18946_n61766# sky130_fd_pr__pfet_01v8 ad=3.3 pd=20.33 as=3.3 ps=20.33 w=20 l=2
X126 TS GP OP w_n8184_n54494# sky130_fd_pr__pfet_01v8 ad=16.5 pd=100.33 as=16.5 ps=100.33 w=100 l=2
X127 a_n18685_n61330# a_n18607_n61526# TS w_n18946_n61766# sky130_fd_pr__pfet_01v8 ad=3.3 pd=20.33 as=3.3 ps=20.33 w=20 l=2
X128 a_n18685_n61330# a_n18607_n61526# TS w_n18946_n61766# sky130_fd_pr__pfet_01v8 ad=3.3 pd=20.33 as=3.3 ps=20.33 w=20 l=2
X129 OP GP TS w_n8184_n54494# sky130_fd_pr__pfet_01v8 ad=16.5 pd=100.33 as=16.5 ps=100.33 w=100 l=2
X130 TS a_n18607_n61526# a_n18685_n61330# w_n18946_n61766# sky130_fd_pr__pfet_01v8 ad=3.3 pd=20.33 as=3.3 ps=20.33 w=20 l=2
X131 TS GN ON w_n8184_n54494# sky130_fd_pr__pfet_01v8 ad=16.5 pd=100.33 as=16.5 ps=100.33 w=100 l=2
X132 a_n18685_n61330# a_n18607_n61526# TS w_n18946_n61766# sky130_fd_pr__pfet_01v8 ad=3.3 pd=20.33 as=3.3 ps=20.33 w=20 l=2
X133 TS a_n18607_n61526# a_n18685_n61330# w_n18946_n61766# sky130_fd_pr__pfet_01v8 ad=3.3 pd=20.33 as=3.3 ps=20.33 w=20 l=2
X134 TS GP OP w_n8184_n54494# sky130_fd_pr__pfet_01v8 ad=16.5 pd=100.33 as=16.5 ps=100.33 w=100 l=2
X135 TS a_n18607_n61526# a_n18685_n61330# w_n18946_n61766# sky130_fd_pr__pfet_01v8 ad=3.3 pd=20.33 as=3.3 ps=20.33 w=20 l=2
X136 a_n18685_n61330# a_n18607_n61526# TS w_n18946_n61766# sky130_fd_pr__pfet_01v8 ad=3.3 pd=20.33 as=3.3 ps=20.33 w=20 l=2
X137 TS a_n18607_n61526# a_n18685_n61330# w_n18946_n61766# sky130_fd_pr__pfet_01v8 ad=3.3 pd=20.33 as=3.3 ps=20.33 w=20 l=2
X138 a_n18685_n61330# a_n18607_n61526# TS w_n18946_n61766# sky130_fd_pr__pfet_01v8 ad=3.3 pd=20.33 as=3.3 ps=20.33 w=20 l=2
X139 OP GP TS w_n8184_n54494# sky130_fd_pr__pfet_01v8 ad=16.5 pd=100.33 as=16.5 ps=100.33 w=100 l=2
X140 ON GN TS w_n8184_n54494# sky130_fd_pr__pfet_01v8 ad=16.5 pd=100.33 as=16.5 ps=100.33 w=100 l=2
X141 TS a_n18607_n61526# a_n18685_n61330# w_n18946_n61766# sky130_fd_pr__pfet_01v8 ad=3.3 pd=20.33 as=3.3 ps=20.33 w=20 l=2
X142 ON GN TS w_n8184_n54494# sky130_fd_pr__pfet_01v8 ad=16.5 pd=100.33 as=16.5 ps=100.33 w=100 l=2
X143 a_n18685_n61330# a_n18607_n61526# TS w_n18946_n61766# sky130_fd_pr__pfet_01v8 ad=3.3 pd=20.33 as=3.3 ps=20.33 w=20 l=2
X144 TS GN ON w_n8184_n54494# sky130_fd_pr__pfet_01v8 ad=39 pd=200.78 as=16.5 ps=100.33 w=100 l=2
X145 TS GP OP w_n8184_n54494# sky130_fd_pr__pfet_01v8 ad=39 pd=200.78 as=16.5 ps=100.33 w=100 l=2
X146 ON GN TS w_n8184_n54494# sky130_fd_pr__pfet_01v8 ad=16.5 pd=100.33 as=16.5 ps=100.33 w=100 l=2
X147 TS a_n18607_n61526# a_n18685_n61330# w_n18946_n61766# sky130_fd_pr__pfet_01v8 ad=3.3 pd=20.33 as=3.3 ps=20.33 w=20 l=2
X148 TS a_n18607_n61526# a_n18685_n61330# w_n18946_n61766# sky130_fd_pr__pfet_01v8 ad=3.3 pd=20.33 as=3.3 ps=20.33 w=20 l=2
X149 ON GN TS w_n8184_n54494# sky130_fd_pr__pfet_01v8 ad=16.5 pd=100.33 as=16.5 ps=100.33 w=100 l=2
C0 GN TS 0.24703p
C1 a_n5450_n10000# OP 4.80424f
C2 a_n5372_n10196# ON 27.6375f
C3 w_n8184_n54494# GN 23.547f
C4 GP TS 0.24708p
C5 a_n5372_n10196# OP 27.6554f
C6 w_n8184_n54494# GP 23.8157f
C7 ON TS 0.12113p
C8 GP GN 29.2342f
C9 w_n8184_n54494# ON 7.71351f
C10 a_n5372_n10196# a_n5450_n10000# 57.3193f
C11 OP TS 0.12113p
C12 ON GN 0.24863p
C13 w_n8184_n54494# OP 7.20178f
C14 a_n18607_n61526# a_n18685_n61330# 0.1283p
C15 w_n18946_n61766# a_n18685_n61330# 6.34415f
C16 ON GP 3.325f
C17 TS a_n18685_n61330# 74.3465f
C18 OP GP 0.25163p
C19 w_n18946_n61766# a_n18607_n61526# 66.42101f
C20 TS a_n18607_n61526# 0.1216p
C21 OP ON 5.13703f
C22 w_n18946_n61766# TS 19.6075f
C23 a_n5450_n10000# ON 2.9801f
C24 w_n8184_n54494# TS 37.8848f
C25 a_n18607_n61526# VSUBS 5.34853f **FLOATING
C26 TS VSUBS 12.0658f **FLOATING
C27 GN VSUBS 8.36987f **FLOATING
C28 GP VSUBS 5.16135f **FLOATING
C29 ON VSUBS 25.6697f **FLOATING
C30 OP VSUBS 25.1793f **FLOATING
C31 a_n5450_n10000# VSUBS 21.0972f **FLOATING
C32 a_n5372_n10196# VSUBS 16.3926f **FLOATING
C33 w_n18946_n61766# VSUBS 0.5773p **FLOATING
C34 w_n8184_n54494# VSUBS 2.0554p **FLOATING
