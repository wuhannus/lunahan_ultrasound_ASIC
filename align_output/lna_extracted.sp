* NGSPICE file created from LNA_PNR.ext - technology: sky130A

.option scale=5m

.subckt LNA_PNR GND VDDA XM1 XM2 XMT XMNL XMNR CINP LNA Zhang diff| sky130 DRC Nets: VDDA|GND|TS|OP|ON|NG
.ends
