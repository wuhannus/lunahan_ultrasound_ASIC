* NGSPICE file created from LNA_FLOW.ext - technology: sky130A

.option scale=5m

.subckt LXML w_n4704_n10452#
X0 a_n2544_n10000# a_n2466_n10196# a_n866_n10000# w_n4704_n10452# sky130_fd_pr__nfet_01v8 ad=0.66u pd=0.02007 as=0.66u ps=0.02007 w=20000 l=1600
X1 a_n866_n10000# a_n2466_n10196# a_n2544_n10000# w_n4704_n10452# sky130_fd_pr__nfet_01v8 ad=0.66u pd=0.02007 as=1.56u ps=0.04016 w=20000 l=1600
X2 a_n866_n10000# a_n2466_n10196# a_n2544_n10000# w_n4704_n10452# sky130_fd_pr__nfet_01v8 ad=1.56u pd=0.04016 as=0.66u ps=0.02007 w=20000 l=1600
X3 w_n4704_n10452# w_n4704_n10452# w_n4704_n10452# w_n4704_n10452# sky130_fd_pr__nfet_01v8 ad=1.56u pd=0.04016 as=6.24u ps=0.16062 w=20000 l=1600
X4 w_n4704_n10452# w_n4704_n10452# w_n4704_n10452# w_n4704_n10452# sky130_fd_pr__nfet_01v8 ad=1.56u pd=0.04016 as=0 ps=0 w=20000 l=1600
.ends

.subckt LXM2
X0 a_n7023_n10000# a_n7423_n10196# a_n7501_n10000# w_n8445_n10435# sky130_fd_pr__pfet_01v8 ad=0.66u pd=0.02007 as=0.66u ps=0.02007 w=20000 l=400
X1 a_n7023_n10000# a_n7423_n10196# a_n7501_n10000# w_n8445_n10435# sky130_fd_pr__pfet_01v8 ad=0.66u pd=0.02007 as=0.66u ps=0.02007 w=20000 l=400
X2 a_n7023_n10000# a_n7423_n10196# a_n7501_n10000# w_n8445_n10435# sky130_fd_pr__pfet_01v8 ad=0.66u pd=0.02007 as=0.66u ps=0.02007 w=20000 l=400
X3 a_n7501_n10000# a_n7423_n10196# a_n7023_n10000# w_n8445_n10435# sky130_fd_pr__pfet_01v8 ad=0.66u pd=0.02007 as=0.66u ps=0.02007 w=20000 l=400
X4 a_n7501_n10000# a_n7423_n10196# a_n7023_n10000# w_n8445_n10435# sky130_fd_pr__pfet_01v8 ad=0.66u pd=0.02007 as=0.66u ps=0.02007 w=20000 l=400
X5 a_n7501_n10000# a_n7423_n10196# a_n7023_n10000# w_n8445_n10435# sky130_fd_pr__pfet_01v8 ad=0.66u pd=0.02007 as=0.66u ps=0.02007 w=20000 l=400
X6 a_n7023_n10000# a_n7423_n10196# a_n7501_n10000# w_n8445_n10435# sky130_fd_pr__pfet_01v8 ad=0.66u pd=0.02007 as=0.66u ps=0.02007 w=20000 l=400
X7 a_n7023_n10000# a_n7423_n10196# a_n7501_n10000# w_n8445_n10435# sky130_fd_pr__pfet_01v8 ad=0.66u pd=0.02007 as=0.66u ps=0.02007 w=20000 l=400
X8 a_n7501_n10000# a_n7423_n10196# a_n7023_n10000# w_n8445_n10435# sky130_fd_pr__pfet_01v8 ad=0.66u pd=0.02007 as=0.66u ps=0.02007 w=20000 l=400
X9 a_n7023_n10000# a_n7423_n10196# a_n7501_n10000# w_n8445_n10435# sky130_fd_pr__pfet_01v8 ad=0.66u pd=0.02007 as=0.66u ps=0.02007 w=20000 l=400
X10 a_n7501_n10000# a_n7423_n10196# a_n7023_n10000# w_n8445_n10435# sky130_fd_pr__pfet_01v8 ad=0.66u pd=0.02007 as=0.66u ps=0.02007 w=20000 l=400
X11 w_n8445_n10435# w_n8445_n10435# w_n8445_n10435# w_n8445_n10435# sky130_fd_pr__pfet_01v8 ad=1.56u pd=0.04016 as=6.24u ps=0.16062 w=20000 l=400
X12 a_n7023_n10000# a_n7423_n10196# a_n7501_n10000# w_n8445_n10435# sky130_fd_pr__pfet_01v8 ad=0.66u pd=0.02007 as=0.66u ps=0.02007 w=20000 l=400
X13 w_n8445_n10435# w_n8445_n10435# w_n8445_n10435# w_n8445_n10435# sky130_fd_pr__pfet_01v8 ad=1.56u pd=0.04016 as=0 ps=0 w=20000 l=400
X14 a_n7501_n10000# a_n7423_n10196# a_n7023_n10000# w_n8445_n10435# sky130_fd_pr__pfet_01v8 ad=0.66u pd=0.02007 as=0.66u ps=0.02007 w=20000 l=400
X15 a_n7023_n10000# a_n7423_n10196# a_n7501_n10000# w_n8445_n10435# sky130_fd_pr__pfet_01v8 ad=0.66u pd=0.02007 as=0.66u ps=0.02007 w=20000 l=400
X16 a_n7501_n10000# a_n7423_n10196# a_n7023_n10000# w_n8445_n10435# sky130_fd_pr__pfet_01v8 ad=0.66u pd=0.02007 as=0.66u ps=0.02007 w=20000 l=400
X17 a_n7501_n10000# a_n7423_n10196# a_n7023_n10000# w_n8445_n10435# sky130_fd_pr__pfet_01v8 ad=0.66u pd=0.02007 as=0.66u ps=0.02007 w=20000 l=400
X18 a_n7023_n10000# a_n7423_n10196# a_n7501_n10000# w_n8445_n10435# sky130_fd_pr__pfet_01v8 ad=0.66u pd=0.02007 as=0.66u ps=0.02007 w=20000 l=400
X19 a_n7501_n10000# a_n7423_n10196# a_n7023_n10000# w_n8445_n10435# sky130_fd_pr__pfet_01v8 ad=0.66u pd=0.02007 as=0.66u ps=0.02007 w=20000 l=400
X20 a_n7023_n10000# a_n7423_n10196# a_n7501_n10000# w_n8445_n10435# sky130_fd_pr__pfet_01v8 ad=0.66u pd=0.02007 as=0.66u ps=0.02007 w=20000 l=400
X21 a_n7023_n10000# a_n7423_n10196# a_n7501_n10000# w_n8445_n10435# sky130_fd_pr__pfet_01v8 ad=0.66u pd=0.02007 as=0.66u ps=0.02007 w=20000 l=400
X22 a_n7501_n10000# a_n7423_n10196# a_n7023_n10000# w_n8445_n10435# sky130_fd_pr__pfet_01v8 ad=0.66u pd=0.02007 as=0.66u ps=0.02007 w=20000 l=400
X23 a_n7501_n10000# a_n7423_n10196# a_n7023_n10000# w_n8445_n10435# sky130_fd_pr__pfet_01v8 ad=0.66u pd=0.02007 as=0.66u ps=0.02007 w=20000 l=400
X24 a_n7023_n10000# a_n7423_n10196# a_n7501_n10000# w_n8445_n10435# sky130_fd_pr__pfet_01v8 ad=0.66u pd=0.02007 as=0.66u ps=0.02007 w=20000 l=400
X25 a_n7501_n10000# a_n7423_n10196# a_n7023_n10000# w_n8445_n10435# sky130_fd_pr__pfet_01v8 ad=0.66u pd=0.02007 as=0.66u ps=0.02007 w=20000 l=400
X26 a_n7501_n10000# a_n7423_n10196# a_n7023_n10000# w_n8445_n10435# sky130_fd_pr__pfet_01v8 ad=0.66u pd=0.02007 as=0.66u ps=0.02007 w=20000 l=400
X27 a_n7023_n10000# a_n7423_n10196# a_n7501_n10000# w_n8445_n10435# sky130_fd_pr__pfet_01v8 ad=0.66u pd=0.02007 as=0.66u ps=0.02007 w=20000 l=400
X28 a_n7501_n10000# a_n7423_n10196# a_n7023_n10000# w_n8445_n10435# sky130_fd_pr__pfet_01v8 ad=1.56u pd=0.04016 as=0.66u ps=0.02007 w=20000 l=400
X29 a_n7023_n10000# a_n7423_n10196# a_n7501_n10000# w_n8445_n10435# sky130_fd_pr__pfet_01v8 ad=0.66u pd=0.02007 as=0.66u ps=0.02007 w=20000 l=400
X30 a_n7501_n10000# a_n7423_n10196# a_n7023_n10000# w_n8445_n10435# sky130_fd_pr__pfet_01v8 ad=0.66u pd=0.02007 as=0.66u ps=0.02007 w=20000 l=400
X31 a_n7023_n10000# a_n7423_n10196# a_n7501_n10000# w_n8445_n10435# sky130_fd_pr__pfet_01v8 ad=0.66u pd=0.02007 as=1.56u ps=0.04016 w=20000 l=400
X32 a_n7023_n10000# a_n7423_n10196# a_n7501_n10000# w_n8445_n10435# sky130_fd_pr__pfet_01v8 ad=0.66u pd=0.02007 as=0.66u ps=0.02007 w=20000 l=400
X33 a_n7501_n10000# a_n7423_n10196# a_n7023_n10000# w_n8445_n10435# sky130_fd_pr__pfet_01v8 ad=0.66u pd=0.02007 as=0.66u ps=0.02007 w=20000 l=400
.ends

.subckt LXMT
X0 a_n18685_n2000# a_n18607_n2196# a_n18207_n2000# w_n19629_n2436# sky130_fd_pr__pfet_01v8 ad=0.132u pd=4.066m as=0.132u ps=4.066m w=4000 l=400
X1 a_n18685_n2000# a_n18607_n2196# a_n18207_n2000# w_n19629_n2436# sky130_fd_pr__pfet_01v8 ad=0.132u pd=4.066m as=0.132u ps=4.066m w=4000 l=400
X2 a_n18207_n2000# a_n18607_n2196# a_n18685_n2000# w_n19629_n2436# sky130_fd_pr__pfet_01v8 ad=0.132u pd=4.066m as=0.132u ps=4.066m w=4000 l=400
X3 a_n18685_n2000# a_n18607_n2196# a_n18207_n2000# w_n19629_n2436# sky130_fd_pr__pfet_01v8 ad=0.132u pd=4.066m as=0.132u ps=4.066m w=4000 l=400
X4 a_n18207_n2000# a_n18607_n2196# a_n18685_n2000# w_n19629_n2436# sky130_fd_pr__pfet_01v8 ad=0.132u pd=4.066m as=0.132u ps=4.066m w=4000 l=400
X5 a_n18207_n2000# a_n18607_n2196# a_n18685_n2000# w_n19629_n2436# sky130_fd_pr__pfet_01v8 ad=0.132u pd=4.066m as=0.132u ps=4.066m w=4000 l=400
X6 a_n18685_n2000# a_n18607_n2196# a_n18207_n2000# w_n19629_n2436# sky130_fd_pr__pfet_01v8 ad=0.132u pd=4.066m as=0.132u ps=4.066m w=4000 l=400
X7 a_n18685_n2000# a_n18607_n2196# a_n18207_n2000# w_n19629_n2436# sky130_fd_pr__pfet_01v8 ad=0.132u pd=4.066m as=0.132u ps=4.066m w=4000 l=400
X8 a_n18685_n2000# a_n18607_n2196# a_n18207_n2000# w_n19629_n2436# sky130_fd_pr__pfet_01v8 ad=0.132u pd=4.066m as=0.132u ps=4.066m w=4000 l=400
X9 a_n18207_n2000# a_n18607_n2196# a_n18685_n2000# w_n19629_n2436# sky130_fd_pr__pfet_01v8 ad=0.132u pd=4.066m as=0.132u ps=4.066m w=4000 l=400
X10 a_n18207_n2000# a_n18607_n2196# a_n18685_n2000# w_n19629_n2436# sky130_fd_pr__pfet_01v8 ad=0.132u pd=4.066m as=0.132u ps=4.066m w=4000 l=400
X11 a_n18207_n2000# a_n18607_n2196# a_n18685_n2000# w_n19629_n2436# sky130_fd_pr__pfet_01v8 ad=0.132u pd=4.066m as=0.132u ps=4.066m w=4000 l=400
X12 a_n18207_n2000# a_n18607_n2196# a_n18685_n2000# w_n19629_n2436# sky130_fd_pr__pfet_01v8 ad=0.132u pd=4.066m as=0.132u ps=4.066m w=4000 l=400
X13 a_n18207_n2000# a_n18607_n2196# a_n18685_n2000# w_n19629_n2436# sky130_fd_pr__pfet_01v8 ad=0.132u pd=4.066m as=0.132u ps=4.066m w=4000 l=400
X14 a_n18685_n2000# a_n18607_n2196# a_n18207_n2000# w_n19629_n2436# sky130_fd_pr__pfet_01v8 ad=0.132u pd=4.066m as=0.132u ps=4.066m w=4000 l=400
X15 a_n18685_n2000# a_n18607_n2196# a_n18207_n2000# w_n19629_n2436# sky130_fd_pr__pfet_01v8 ad=0.132u pd=4.066m as=0.132u ps=4.066m w=4000 l=400
X16 a_n18685_n2000# a_n18607_n2196# a_n18207_n2000# w_n19629_n2436# sky130_fd_pr__pfet_01v8 ad=0.132u pd=4.066m as=0.132u ps=4.066m w=4000 l=400
X17 a_n18207_n2000# a_n18607_n2196# a_n18685_n2000# w_n19629_n2436# sky130_fd_pr__pfet_01v8 ad=0.132u pd=4.066m as=0.132u ps=4.066m w=4000 l=400
X18 a_n18685_n2000# a_n18607_n2196# a_n18207_n2000# w_n19629_n2436# sky130_fd_pr__pfet_01v8 ad=0.132u pd=4.066m as=0.132u ps=4.066m w=4000 l=400
X19 a_n18685_n2000# a_n18607_n2196# a_n18207_n2000# w_n19629_n2436# sky130_fd_pr__pfet_01v8 ad=0.132u pd=4.066m as=0.132u ps=4.066m w=4000 l=400
X20 a_n18685_n2000# a_n18607_n2196# a_n18207_n2000# w_n19629_n2436# sky130_fd_pr__pfet_01v8 ad=0.312u pd=8.156m as=0.132u ps=4.066m w=4000 l=400
X21 a_n18685_n2000# a_n18607_n2196# a_n18207_n2000# w_n19629_n2436# sky130_fd_pr__pfet_01v8 ad=0.132u pd=4.066m as=0.132u ps=4.066m w=4000 l=400
X22 a_n18207_n2000# a_n18607_n2196# a_n18685_n2000# w_n19629_n2436# sky130_fd_pr__pfet_01v8 ad=0.132u pd=4.066m as=0.132u ps=4.066m w=4000 l=400
X23 a_n18207_n2000# a_n18607_n2196# a_n18685_n2000# w_n19629_n2436# sky130_fd_pr__pfet_01v8 ad=0.132u pd=4.066m as=0.132u ps=4.066m w=4000 l=400
X24 a_n18207_n2000# a_n18607_n2196# a_n18685_n2000# w_n19629_n2436# sky130_fd_pr__pfet_01v8 ad=0.132u pd=4.066m as=0.132u ps=4.066m w=4000 l=400
X25 a_n18685_n2000# a_n18607_n2196# a_n18207_n2000# w_n19629_n2436# sky130_fd_pr__pfet_01v8 ad=0.132u pd=4.066m as=0.132u ps=4.066m w=4000 l=400
X26 a_n18685_n2000# a_n18607_n2196# a_n18207_n2000# w_n19629_n2436# sky130_fd_pr__pfet_01v8 ad=0.132u pd=4.066m as=0.132u ps=4.066m w=4000 l=400
X27 w_n19629_n2436# w_n19629_n2436# w_n19629_n2436# w_n19629_n2436# sky130_fd_pr__pfet_01v8 ad=0.312u pd=8.156m as=1.248u ps=0.03262 w=4000 l=400
X28 a_n18685_n2000# a_n18607_n2196# a_n18207_n2000# w_n19629_n2436# sky130_fd_pr__pfet_01v8 ad=0.132u pd=4.066m as=0.132u ps=4.066m w=4000 l=400
X29 a_n18207_n2000# a_n18607_n2196# a_n18685_n2000# w_n19629_n2436# sky130_fd_pr__pfet_01v8 ad=0.132u pd=4.066m as=0.132u ps=4.066m w=4000 l=400
X30 a_n18685_n2000# a_n18607_n2196# a_n18207_n2000# w_n19629_n2436# sky130_fd_pr__pfet_01v8 ad=0.132u pd=4.066m as=0.132u ps=4.066m w=4000 l=400
X31 a_n18685_n2000# a_n18607_n2196# a_n18207_n2000# w_n19629_n2436# sky130_fd_pr__pfet_01v8 ad=0.132u pd=4.066m as=0.132u ps=4.066m w=4000 l=400
X32 a_n18207_n2000# a_n18607_n2196# a_n18685_n2000# w_n19629_n2436# sky130_fd_pr__pfet_01v8 ad=0.132u pd=4.066m as=0.132u ps=4.066m w=4000 l=400
X33 a_n18207_n2000# a_n18607_n2196# a_n18685_n2000# w_n19629_n2436# sky130_fd_pr__pfet_01v8 ad=0.132u pd=4.066m as=0.132u ps=4.066m w=4000 l=400
X34 a_n18207_n2000# a_n18607_n2196# a_n18685_n2000# w_n19629_n2436# sky130_fd_pr__pfet_01v8 ad=0.132u pd=4.066m as=0.132u ps=4.066m w=4000 l=400
X35 a_n18207_n2000# a_n18607_n2196# a_n18685_n2000# w_n19629_n2436# sky130_fd_pr__pfet_01v8 ad=0.132u pd=4.066m as=0.132u ps=4.066m w=4000 l=400
X36 a_n18685_n2000# a_n18607_n2196# a_n18207_n2000# w_n19629_n2436# sky130_fd_pr__pfet_01v8 ad=0.132u pd=4.066m as=0.132u ps=4.066m w=4000 l=400
X37 a_n18207_n2000# a_n18607_n2196# a_n18685_n2000# w_n19629_n2436# sky130_fd_pr__pfet_01v8 ad=0.132u pd=4.066m as=0.132u ps=4.066m w=4000 l=400
X38 a_n18685_n2000# a_n18607_n2196# a_n18207_n2000# w_n19629_n2436# sky130_fd_pr__pfet_01v8 ad=0.132u pd=4.066m as=0.132u ps=4.066m w=4000 l=400
X39 a_n18207_n2000# a_n18607_n2196# a_n18685_n2000# w_n19629_n2436# sky130_fd_pr__pfet_01v8 ad=0.132u pd=4.066m as=0.132u ps=4.066m w=4000 l=400
X40 w_n19629_n2436# w_n19629_n2436# w_n19629_n2436# w_n19629_n2436# sky130_fd_pr__pfet_01v8 ad=0.312u pd=8.156m as=0 ps=0 w=4000 l=400
X41 a_n18207_n2000# a_n18607_n2196# a_n18685_n2000# w_n19629_n2436# sky130_fd_pr__pfet_01v8 ad=0.132u pd=4.066m as=0.132u ps=4.066m w=4000 l=400
X42 a_n18685_n2000# a_n18607_n2196# a_n18207_n2000# w_n19629_n2436# sky130_fd_pr__pfet_01v8 ad=0.132u pd=4.066m as=0.132u ps=4.066m w=4000 l=400
X43 a_n18207_n2000# a_n18607_n2196# a_n18685_n2000# w_n19629_n2436# sky130_fd_pr__pfet_01v8 ad=0.132u pd=4.066m as=0.132u ps=4.066m w=4000 l=400
X44 a_n18685_n2000# a_n18607_n2196# a_n18207_n2000# w_n19629_n2436# sky130_fd_pr__pfet_01v8 ad=0.132u pd=4.066m as=0.132u ps=4.066m w=4000 l=400
X45 a_n18207_n2000# a_n18607_n2196# a_n18685_n2000# w_n19629_n2436# sky130_fd_pr__pfet_01v8 ad=0.132u pd=4.066m as=0.312u ps=8.156m w=4000 l=400
X46 a_n18207_n2000# a_n18607_n2196# a_n18685_n2000# w_n19629_n2436# sky130_fd_pr__pfet_01v8 ad=0.132u pd=4.066m as=0.132u ps=4.066m w=4000 l=400
X47 a_n18207_n2000# a_n18607_n2196# a_n18685_n2000# w_n19629_n2436# sky130_fd_pr__pfet_01v8 ad=0.132u pd=4.066m as=0.132u ps=4.066m w=4000 l=400
X48 a_n18685_n2000# a_n18607_n2196# a_n18207_n2000# w_n19629_n2436# sky130_fd_pr__pfet_01v8 ad=0.132u pd=4.066m as=0.132u ps=4.066m w=4000 l=400
X49 a_n18685_n2000# a_n18607_n2196# a_n18207_n2000# w_n19629_n2436# sky130_fd_pr__pfet_01v8 ad=0.132u pd=4.066m as=0.132u ps=4.066m w=4000 l=400
X50 a_n18207_n2000# a_n18607_n2196# a_n18685_n2000# w_n19629_n2436# sky130_fd_pr__pfet_01v8 ad=0.132u pd=4.066m as=0.132u ps=4.066m w=4000 l=400
X51 a_n18685_n2000# a_n18607_n2196# a_n18207_n2000# w_n19629_n2436# sky130_fd_pr__pfet_01v8 ad=0.132u pd=4.066m as=0.132u ps=4.066m w=4000 l=400
X52 a_n18207_n2000# a_n18607_n2196# a_n18685_n2000# w_n19629_n2436# sky130_fd_pr__pfet_01v8 ad=0.132u pd=4.066m as=0.132u ps=4.066m w=4000 l=400
X53 a_n18685_n2000# a_n18607_n2196# a_n18207_n2000# w_n19629_n2436# sky130_fd_pr__pfet_01v8 ad=0.132u pd=4.066m as=0.132u ps=4.066m w=4000 l=400
X54 a_n18685_n2000# a_n18607_n2196# a_n18207_n2000# w_n19629_n2436# sky130_fd_pr__pfet_01v8 ad=0.132u pd=4.066m as=0.132u ps=4.066m w=4000 l=400
X55 a_n18685_n2000# a_n18607_n2196# a_n18207_n2000# w_n19629_n2436# sky130_fd_pr__pfet_01v8 ad=0.132u pd=4.066m as=0.132u ps=4.066m w=4000 l=400
X56 a_n18685_n2000# a_n18607_n2196# a_n18207_n2000# w_n19629_n2436# sky130_fd_pr__pfet_01v8 ad=0.132u pd=4.066m as=0.132u ps=4.066m w=4000 l=400
X57 a_n18207_n2000# a_n18607_n2196# a_n18685_n2000# w_n19629_n2436# sky130_fd_pr__pfet_01v8 ad=0.132u pd=4.066m as=0.132u ps=4.066m w=4000 l=400
X58 a_n18207_n2000# a_n18607_n2196# a_n18685_n2000# w_n19629_n2436# sky130_fd_pr__pfet_01v8 ad=0.132u pd=4.066m as=0.132u ps=4.066m w=4000 l=400
X59 a_n18207_n2000# a_n18607_n2196# a_n18685_n2000# w_n19629_n2436# sky130_fd_pr__pfet_01v8 ad=0.132u pd=4.066m as=0.132u ps=4.066m w=4000 l=400
X60 a_n18207_n2000# a_n18607_n2196# a_n18685_n2000# w_n19629_n2436# sky130_fd_pr__pfet_01v8 ad=0.132u pd=4.066m as=0.132u ps=4.066m w=4000 l=400
X61 a_n18685_n2000# a_n18607_n2196# a_n18207_n2000# w_n19629_n2436# sky130_fd_pr__pfet_01v8 ad=0.132u pd=4.066m as=0.132u ps=4.066m w=4000 l=400
X62 a_n18207_n2000# a_n18607_n2196# a_n18685_n2000# w_n19629_n2436# sky130_fd_pr__pfet_01v8 ad=0.132u pd=4.066m as=0.132u ps=4.066m w=4000 l=400
X63 a_n18685_n2000# a_n18607_n2196# a_n18207_n2000# w_n19629_n2436# sky130_fd_pr__pfet_01v8 ad=0.132u pd=4.066m as=0.132u ps=4.066m w=4000 l=400
X64 a_n18207_n2000# a_n18607_n2196# a_n18685_n2000# w_n19629_n2436# sky130_fd_pr__pfet_01v8 ad=0.132u pd=4.066m as=0.132u ps=4.066m w=4000 l=400
X65 a_n18685_n2000# a_n18607_n2196# a_n18207_n2000# w_n19629_n2436# sky130_fd_pr__pfet_01v8 ad=0.132u pd=4.066m as=0.132u ps=4.066m w=4000 l=400
X66 a_n18685_n2000# a_n18607_n2196# a_n18207_n2000# w_n19629_n2436# sky130_fd_pr__pfet_01v8 ad=0.132u pd=4.066m as=0.132u ps=4.066m w=4000 l=400
X67 a_n18685_n2000# a_n18607_n2196# a_n18207_n2000# w_n19629_n2436# sky130_fd_pr__pfet_01v8 ad=0.132u pd=4.066m as=0.132u ps=4.066m w=4000 l=400
X68 a_n18207_n2000# a_n18607_n2196# a_n18685_n2000# w_n19629_n2436# sky130_fd_pr__pfet_01v8 ad=0.132u pd=4.066m as=0.132u ps=4.066m w=4000 l=400
X69 a_n18685_n2000# a_n18607_n2196# a_n18207_n2000# w_n19629_n2436# sky130_fd_pr__pfet_01v8 ad=0.132u pd=4.066m as=0.132u ps=4.066m w=4000 l=400
X70 a_n18685_n2000# a_n18607_n2196# a_n18207_n2000# w_n19629_n2436# sky130_fd_pr__pfet_01v8 ad=0.132u pd=4.066m as=0.132u ps=4.066m w=4000 l=400
X71 a_n18685_n2000# a_n18607_n2196# a_n18207_n2000# w_n19629_n2436# sky130_fd_pr__pfet_01v8 ad=0.132u pd=4.066m as=0.132u ps=4.066m w=4000 l=400
X72 a_n18207_n2000# a_n18607_n2196# a_n18685_n2000# w_n19629_n2436# sky130_fd_pr__pfet_01v8 ad=0.132u pd=4.066m as=0.132u ps=4.066m w=4000 l=400
X73 a_n18207_n2000# a_n18607_n2196# a_n18685_n2000# w_n19629_n2436# sky130_fd_pr__pfet_01v8 ad=0.132u pd=4.066m as=0.132u ps=4.066m w=4000 l=400
X74 a_n18685_n2000# a_n18607_n2196# a_n18207_n2000# w_n19629_n2436# sky130_fd_pr__pfet_01v8 ad=0.132u pd=4.066m as=0.132u ps=4.066m w=4000 l=400
X75 a_n18685_n2000# a_n18607_n2196# a_n18207_n2000# w_n19629_n2436# sky130_fd_pr__pfet_01v8 ad=0.132u pd=4.066m as=0.132u ps=4.066m w=4000 l=400
X76 a_n18207_n2000# a_n18607_n2196# a_n18685_n2000# w_n19629_n2436# sky130_fd_pr__pfet_01v8 ad=0.132u pd=4.066m as=0.132u ps=4.066m w=4000 l=400
X77 a_n18207_n2000# a_n18607_n2196# a_n18685_n2000# w_n19629_n2436# sky130_fd_pr__pfet_01v8 ad=0.132u pd=4.066m as=0.132u ps=4.066m w=4000 l=400
X78 a_n18685_n2000# a_n18607_n2196# a_n18207_n2000# w_n19629_n2436# sky130_fd_pr__pfet_01v8 ad=0.132u pd=4.066m as=0.132u ps=4.066m w=4000 l=400
X79 a_n18207_n2000# a_n18607_n2196# a_n18685_n2000# w_n19629_n2436# sky130_fd_pr__pfet_01v8 ad=0.132u pd=4.066m as=0.132u ps=4.066m w=4000 l=400
X80 a_n18207_n2000# a_n18607_n2196# a_n18685_n2000# w_n19629_n2436# sky130_fd_pr__pfet_01v8 ad=0.132u pd=4.066m as=0.132u ps=4.066m w=4000 l=400
X81 a_n18207_n2000# a_n18607_n2196# a_n18685_n2000# w_n19629_n2436# sky130_fd_pr__pfet_01v8 ad=0.132u pd=4.066m as=0.132u ps=4.066m w=4000 l=400
.ends

.subckt LXM1
X0 a_n7023_n10000# a_n7423_n10196# a_n7501_n10000# w_n8445_n10435# sky130_fd_pr__pfet_01v8 ad=0.66u pd=0.02007 as=0.66u ps=0.02007 w=20000 l=400
X1 a_n7023_n10000# a_n7423_n10196# a_n7501_n10000# w_n8445_n10435# sky130_fd_pr__pfet_01v8 ad=0.66u pd=0.02007 as=0.66u ps=0.02007 w=20000 l=400
X2 a_n7023_n10000# a_n7423_n10196# a_n7501_n10000# w_n8445_n10435# sky130_fd_pr__pfet_01v8 ad=0.66u pd=0.02007 as=0.66u ps=0.02007 w=20000 l=400
X3 a_n7501_n10000# a_n7423_n10196# a_n7023_n10000# w_n8445_n10435# sky130_fd_pr__pfet_01v8 ad=0.66u pd=0.02007 as=0.66u ps=0.02007 w=20000 l=400
X4 a_n7501_n10000# a_n7423_n10196# a_n7023_n10000# w_n8445_n10435# sky130_fd_pr__pfet_01v8 ad=0.66u pd=0.02007 as=0.66u ps=0.02007 w=20000 l=400
X5 a_n7501_n10000# a_n7423_n10196# a_n7023_n10000# w_n8445_n10435# sky130_fd_pr__pfet_01v8 ad=0.66u pd=0.02007 as=0.66u ps=0.02007 w=20000 l=400
X6 a_n7023_n10000# a_n7423_n10196# a_n7501_n10000# w_n8445_n10435# sky130_fd_pr__pfet_01v8 ad=0.66u pd=0.02007 as=0.66u ps=0.02007 w=20000 l=400
X7 a_n7023_n10000# a_n7423_n10196# a_n7501_n10000# w_n8445_n10435# sky130_fd_pr__pfet_01v8 ad=0.66u pd=0.02007 as=0.66u ps=0.02007 w=20000 l=400
X8 a_n7501_n10000# a_n7423_n10196# a_n7023_n10000# w_n8445_n10435# sky130_fd_pr__pfet_01v8 ad=0.66u pd=0.02007 as=0.66u ps=0.02007 w=20000 l=400
X9 a_n7023_n10000# a_n7423_n10196# a_n7501_n10000# w_n8445_n10435# sky130_fd_pr__pfet_01v8 ad=0.66u pd=0.02007 as=0.66u ps=0.02007 w=20000 l=400
X10 a_n7501_n10000# a_n7423_n10196# a_n7023_n10000# w_n8445_n10435# sky130_fd_pr__pfet_01v8 ad=0.66u pd=0.02007 as=0.66u ps=0.02007 w=20000 l=400
X11 w_n8445_n10435# w_n8445_n10435# w_n8445_n10435# w_n8445_n10435# sky130_fd_pr__pfet_01v8 ad=1.56u pd=0.04016 as=6.24u ps=0.16062 w=20000 l=400
X12 a_n7023_n10000# a_n7423_n10196# a_n7501_n10000# w_n8445_n10435# sky130_fd_pr__pfet_01v8 ad=0.66u pd=0.02007 as=0.66u ps=0.02007 w=20000 l=400
X13 w_n8445_n10435# w_n8445_n10435# w_n8445_n10435# w_n8445_n10435# sky130_fd_pr__pfet_01v8 ad=1.56u pd=0.04016 as=0 ps=0 w=20000 l=400
X14 a_n7501_n10000# a_n7423_n10196# a_n7023_n10000# w_n8445_n10435# sky130_fd_pr__pfet_01v8 ad=0.66u pd=0.02007 as=0.66u ps=0.02007 w=20000 l=400
X15 a_n7023_n10000# a_n7423_n10196# a_n7501_n10000# w_n8445_n10435# sky130_fd_pr__pfet_01v8 ad=0.66u pd=0.02007 as=0.66u ps=0.02007 w=20000 l=400
X16 a_n7501_n10000# a_n7423_n10196# a_n7023_n10000# w_n8445_n10435# sky130_fd_pr__pfet_01v8 ad=0.66u pd=0.02007 as=0.66u ps=0.02007 w=20000 l=400
X17 a_n7501_n10000# a_n7423_n10196# a_n7023_n10000# w_n8445_n10435# sky130_fd_pr__pfet_01v8 ad=0.66u pd=0.02007 as=0.66u ps=0.02007 w=20000 l=400
X18 a_n7023_n10000# a_n7423_n10196# a_n7501_n10000# w_n8445_n10435# sky130_fd_pr__pfet_01v8 ad=0.66u pd=0.02007 as=0.66u ps=0.02007 w=20000 l=400
X19 a_n7501_n10000# a_n7423_n10196# a_n7023_n10000# w_n8445_n10435# sky130_fd_pr__pfet_01v8 ad=0.66u pd=0.02007 as=0.66u ps=0.02007 w=20000 l=400
X20 a_n7023_n10000# a_n7423_n10196# a_n7501_n10000# w_n8445_n10435# sky130_fd_pr__pfet_01v8 ad=0.66u pd=0.02007 as=0.66u ps=0.02007 w=20000 l=400
X21 a_n7023_n10000# a_n7423_n10196# a_n7501_n10000# w_n8445_n10435# sky130_fd_pr__pfet_01v8 ad=0.66u pd=0.02007 as=0.66u ps=0.02007 w=20000 l=400
X22 a_n7501_n10000# a_n7423_n10196# a_n7023_n10000# w_n8445_n10435# sky130_fd_pr__pfet_01v8 ad=0.66u pd=0.02007 as=0.66u ps=0.02007 w=20000 l=400
X23 a_n7501_n10000# a_n7423_n10196# a_n7023_n10000# w_n8445_n10435# sky130_fd_pr__pfet_01v8 ad=0.66u pd=0.02007 as=0.66u ps=0.02007 w=20000 l=400
X24 a_n7023_n10000# a_n7423_n10196# a_n7501_n10000# w_n8445_n10435# sky130_fd_pr__pfet_01v8 ad=0.66u pd=0.02007 as=0.66u ps=0.02007 w=20000 l=400
X25 a_n7501_n10000# a_n7423_n10196# a_n7023_n10000# w_n8445_n10435# sky130_fd_pr__pfet_01v8 ad=0.66u pd=0.02007 as=0.66u ps=0.02007 w=20000 l=400
X26 a_n7501_n10000# a_n7423_n10196# a_n7023_n10000# w_n8445_n10435# sky130_fd_pr__pfet_01v8 ad=0.66u pd=0.02007 as=0.66u ps=0.02007 w=20000 l=400
X27 a_n7023_n10000# a_n7423_n10196# a_n7501_n10000# w_n8445_n10435# sky130_fd_pr__pfet_01v8 ad=0.66u pd=0.02007 as=0.66u ps=0.02007 w=20000 l=400
X28 a_n7501_n10000# a_n7423_n10196# a_n7023_n10000# w_n8445_n10435# sky130_fd_pr__pfet_01v8 ad=1.56u pd=0.04016 as=0.66u ps=0.02007 w=20000 l=400
X29 a_n7023_n10000# a_n7423_n10196# a_n7501_n10000# w_n8445_n10435# sky130_fd_pr__pfet_01v8 ad=0.66u pd=0.02007 as=0.66u ps=0.02007 w=20000 l=400
X30 a_n7501_n10000# a_n7423_n10196# a_n7023_n10000# w_n8445_n10435# sky130_fd_pr__pfet_01v8 ad=0.66u pd=0.02007 as=0.66u ps=0.02007 w=20000 l=400
X31 a_n7023_n10000# a_n7423_n10196# a_n7501_n10000# w_n8445_n10435# sky130_fd_pr__pfet_01v8 ad=0.66u pd=0.02007 as=1.56u ps=0.04016 w=20000 l=400
X32 a_n7023_n10000# a_n7423_n10196# a_n7501_n10000# w_n8445_n10435# sky130_fd_pr__pfet_01v8 ad=0.66u pd=0.02007 as=0.66u ps=0.02007 w=20000 l=400
X33 a_n7501_n10000# a_n7423_n10196# a_n7023_n10000# w_n8445_n10435# sky130_fd_pr__pfet_01v8 ad=0.66u pd=0.02007 as=0.66u ps=0.02007 w=20000 l=400
.ends

.subckt LXMR w_n4704_n10452#
X0 a_n2544_n10000# a_n2466_n10196# a_n866_n10000# w_n4704_n10452# sky130_fd_pr__nfet_01v8 ad=0.66u pd=0.02007 as=0.66u ps=0.02007 w=20000 l=1600
X1 a_n866_n10000# a_n2466_n10196# a_n2544_n10000# w_n4704_n10452# sky130_fd_pr__nfet_01v8 ad=0.66u pd=0.02007 as=1.56u ps=0.04016 w=20000 l=1600
X2 a_n866_n10000# a_n2466_n10196# a_n2544_n10000# w_n4704_n10452# sky130_fd_pr__nfet_01v8 ad=1.56u pd=0.04016 as=0.66u ps=0.02007 w=20000 l=1600
X3 w_n4704_n10452# w_n4704_n10452# w_n4704_n10452# w_n4704_n10452# sky130_fd_pr__nfet_01v8 ad=1.56u pd=0.04016 as=6.24u ps=0.16062 w=20000 l=1600
X4 w_n4704_n10452# w_n4704_n10452# w_n4704_n10452# w_n4704_n10452# sky130_fd_pr__nfet_01v8 ad=1.56u pd=0.04016 as=0 ps=0 w=20000 l=1600
.ends

.subckt LNA_FLOW
XLXML_0 w_n3704_5748# LXML
XLXM2_0 LXM2
XLXMT_0 LXMT
XLXM1_0 LXM1
XLXMR_0 w_14096_5748# LXMR
.ends
