* SAR ADC — BAG-Generated (9.6-bit ENOB, 1.2MS/s)
* Cu=10.0fF (kT/C verified), C_total=1280fF
* Comparator noise: <580µV, LSB=1.76mV
* Expected power: 700µW
* (Full transistor-level netlist — see afe/adc/sar_adc_transistor_level.sp)
.END
