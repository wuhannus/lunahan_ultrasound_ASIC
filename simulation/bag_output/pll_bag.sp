* PLL — BAG-Generated (16.0MHz → 50.025MHz)
* VCO: 200.1MHz, Lock: 28.4µs, Jitter: 38.2ps RMS
* Phase noise: -92.5dBc/Hz @100kHz, Power: 2.0mW
* (Full transistor-level netlist — see afe/pll/pll_transistor_level.sp)
.END
