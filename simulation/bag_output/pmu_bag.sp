* PMU — BAG-Generated (Boost + 2× LDO)
* Outputs: VANA=1.8V, VDIG=1.8V, VTX=6.0-14.1V
* Efficiency: 78.3%, Ripple: <12.0mVpp
* (Full transistor-level netlist — see afe/pmu/pmu_transistor_level.sp)
.END
