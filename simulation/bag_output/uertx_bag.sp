* UERTX — BAG-Generated (14.0Vpp, 44.2% saving)
* Dead-time: 120.0ns, Lrec=330.0µH
* Efficiency: 85.3%
* (Full transistor-level netlist — see afe/tx_driver/uertx_transistor_level.sp)
.END
