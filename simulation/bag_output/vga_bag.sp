* VGA — BAG-Generated (R-2R PGA, 0.0-46.0dB, 64 steps)
* R-2R resistor: 1200Ω, Opamp gm=2.0mS, BW>200.0kHz
* Expected power: 1400µW
* (Full transistor-level netlist — see afe/vga/vga_transistor_level.sp)
.END
